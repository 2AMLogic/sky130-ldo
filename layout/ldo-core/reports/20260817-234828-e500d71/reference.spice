* Mechanically translated LVS reference netlist for `ldo_core`, generated by
* layout/bin/gen-ldo-reference-netlist.py from design/ldo_3v3in_1v8out.sch's
* own xschem netlist (issue #17). MOS model names translated to `klt extract`'s
* generic nfet/pfet classes; resistor model names already match flavor-specific
* classes. Capacitors are dropped (no klt gen capacitor generator exists --
* see layout/ldo-core/floorplan.md's Known gap). Regenerate rather than hand-edit.
.SUBCKT ldo_core VOUT VREF EN VIN
R_BIAS VIN NB 0 res_high_po L=1500U W=0.42U
M_BIASN1 NB NB BIAS_ENN 0 nfet L=1U W=4U
M_ENN BIAS_ENN EN 0 0 nfet L=0.5U W=10U
M_BIASN2 BIASP NB BIAS_ENN 0 nfet L=1U W=4U
M_BIASP1 BIASP BIASP VIN VIN pfet L=1U W=10U
M_ENP2 BIASP EN VIN VIN pfet L=0.5U W=10U
M_TAIL EA_TAIL BIASP VIN VIN pfet L=2U W=20U
M_IN1 EA_D1 FB EA_TAIL VIN pfet L=2U W=10U
M_IN2 EA_OUT VREF EA_TAIL VIN pfet L=2U W=10U
M_MIR1 EA_D1 EA_D1 AMP_ENN 0 nfet L=4U W=10U
M_MIR2 EA_OUT EA_D1 AMP_ENN 0 nfet L=4U W=10U
M_ENN2 AMP_ENN EN 0 0 nfet L=0.5U W=10U
M_ENP EA_OUT EN VIN VIN pfet L=0.5U W=10U
M_PASS VOUT EA_OUT VIN VIN pfet L=0.5U W=2500U
R_FB_A VOUT FB 0 res_xhigh_po L=180U W=0.42U
R_FB_B FB N_FBB 0 res_xhigh_po L=180U W=0.42U
R_FB_C N_FBB 0 0 res_xhigh_po L=180U W=0.42U
M_SENSE CL_SNS EA_OUT VIN VIN pfet L=0.5U W=0.42U
M_CLN1 CL_SNS CL_SNS AMP_ENN 0 nfet L=1U W=20U
M_CLN2 CL_CMP CL_SNS AMP_ENN 0 nfet L=1U W=1.6U
M_CLP CL_CMP BIASP VIN VIN pfet L=1U W=10U
M_CLIM EA_OUT CL_CMP VIN VIN pfet L=0.5U W=20U
M_ENP3 CL_CMP EN VIN VIN pfet L=0.5U W=2U
M_INVP ENB EN VIN VIN pfet L=0.5U W=2U
M_INVN ENB EN 0 0 nfet L=0.5U W=1U
M_SSDIS SS ENB 0 0 nfet L=0.5U W=2U
M_SSCHG SS BIASP VIN VIN pfet L=8U W=1U
M_IN2S EA_OUT SS EA_TAIL VIN pfet L=2U W=10U
.ENDS ldo_core
