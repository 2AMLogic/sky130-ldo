* extracted by klt extract --deck sky130

* cell ldo_core
* pin vsubs
.SUBCKT ldo_core vsubs
* device instance $1 r0 *1 0.92,42.84 nfet
M$1 \$15 \$4 \$14 vsubs nfet L=1U W=4U AS=1.68P AD=1.68P PS=8.84U PD=8.84U
* device instance $2 r0 *1 14.1,42.84 nfet
M$2 \$17 \$6 \$16 vsubs nfet L=1U W=4U AS=1.68P AD=1.68P PS=8.84U PD=8.84U
* device instance $3 r0 *1 7.51,45.84 nfet
M$3 \$22 \$5 \$21 vsubs nfet L=0.5U W=10U AS=4.2P AD=4.2P PS=20.84U PD=20.84U
* device instance $4 r0 *1 29.19,76.96 nfet
M$4 \$81 \$27 \$80 vsubs nfet L=0.5U W=10U AS=4.2P AD=2.1P PS=20.84U PD=10.42U
* device instance $5 r0 *1 30.11,76.96 nfet
M$5 \$82 \$29 \$81 vsubs nfet L=0.5U W=10U AS=2.1P AD=4.2P PS=10.42U PD=20.84U
* device instance $6 r0 *1 36.45,76.96 nfet
M$6 \$84 \$30 \$83 vsubs nfet L=0.5U W=10U AS=4.2P AD=2.1P PS=20.84U PD=10.42U
* device instance $7 r0 *1 37.37,76.96 nfet
M$7 \$85 \$31 \$84 vsubs nfet L=0.5U W=10U AS=2.1P AD=4.2P PS=10.42U PD=20.84U
* device instance $8 r0 *1 43.71,76.96 nfet
M$8 \$87 \$32 \$86 vsubs nfet L=0.5U W=10U AS=4.2P AD=4.2P PS=20.84U PD=20.84U
* device instance $9 r0 *1 21.09,45.99 pfet
M$9 \$24 \$18 \$23 \$33 pfet L=1U W=10U AS=4.2P AD=2.1P PS=20.84U PD=10.42U
* device instance $10 r0 *1 22.51,45.99 pfet
M$10 \$25 \$19 \$24 \$33 pfet L=1U W=10U AS=2.1P AD=4.2P PS=10.42U PD=20.84U
* device instance $11 r0 *1 29.4,45.99 pfet
M$11 \$28 \$20 \$26 \$34 pfet L=0.5U W=10U AS=4.2P AD=4.2P PS=20.84U PD=20.84U
* device instance $12 r0 *1 12.47,77.11 pfet
M$12 \$64 \$39 \$62 \$93 pfet L=1U W=10U AS=4.2P AD=2.1P PS=20.84U PD=10.42U
* device instance $13 r0 *1 13.89,77.11 pfet
M$13 \$67 \$40 \$64 \$93 pfet L=1U W=10U AS=2.1P AD=4.2P PS=10.42U PD=20.84U
* device instance $14 r0 *1 21.03,77.11 pfet
M$14 \$76 \$41 \$74 \$92 pfet L=1U W=10U AS=4.2P AD=2.1P PS=20.84U PD=10.42U
* device instance $15 r0 *1 22.45,77.11 pfet
M$15 \$79 \$42 \$76 \$92 pfet L=1U W=10U AS=2.1P AD=4.2P PS=10.42U PD=20.84U
* device instance $16 r0 *1 50.2,77.11 pfet
M$16 \$89 \$43 \$88 \$90 pfet L=0.5U W=10U AS=4.2P AD=4.2P PS=20.84U PD=20.84U
* device instance $17 r0 *1 1.07,82.11 pfet
M$17 \$47 \$35 \$44 \$91 pfet L=1U W=20U AS=8.4P AD=4.2P PS=40.84U PD=20.42U
* device instance $18 r0 *1 2.49,82.11 pfet
M$18 \$49 \$36 \$47 \$91 pfet L=1U W=20U AS=4.2P AD=4.2P PS=20.42U PD=20.42U
* device instance $19 r0 *1 3.91,82.11 pfet
M$19 \$52 \$37 \$49 \$91 pfet L=1U W=20U AS=4.2P AD=4.2P PS=20.42U PD=20.42U
* device instance $20 r0 *1 5.33,82.11 pfet
M$20 \$54 \$38 \$52 \$91 pfet L=1U W=20U AS=4.2P AD=8.4P PS=20.42U PD=40.84U
* device instance $21 r0 *1 0.82,163.23 pfet
M$21 \$95 \$45 \$94 \$120 pfet L=0.5U W=100U AS=42P AD=21P PS=200.84U PD=100.42U
* device instance $22 r0 *1 1.74,163.23 pfet
M$22 \$96 \$46 \$95 \$120 pfet L=0.5U W=100U AS=21P AD=21P PS=100.42U PD=100.42U
* device instance $23 r0 *1 2.66,163.23 pfet
M$23 \$97 \$48 \$96 \$120 pfet L=0.5U W=100U AS=21P AD=21P PS=100.42U PD=100.42U
* device instance $24 r0 *1 3.58,163.23 pfet
M$24 \$98 \$50 \$97 \$120 pfet L=0.5U W=100U AS=21P AD=21P PS=100.42U PD=100.42U
* device instance $25 r0 *1 4.5,163.23 pfet
M$25 \$99 \$51 \$98 \$120 pfet L=0.5U W=100U AS=21P AD=21P PS=100.42U PD=100.42U
* device instance $26 r0 *1 5.42,163.23 pfet
M$26 \$100 \$53 \$99 \$120 pfet L=0.5U W=100U AS=21P AD=21P PS=100.42U
+ PD=100.42U
* device instance $27 r0 *1 6.34,163.23 pfet
M$27 \$101 \$55 \$100 \$120 pfet L=0.5U W=100U AS=21P AD=21P PS=100.42U
+ PD=100.42U
* device instance $28 r0 *1 7.26,163.23 pfet
M$28 \$102 \$56 \$101 \$120 pfet L=0.5U W=100U AS=21P AD=21P PS=100.42U
+ PD=100.42U
* device instance $29 r0 *1 8.18,163.23 pfet
M$29 \$103 \$57 \$102 \$120 pfet L=0.5U W=100U AS=21P AD=21P PS=100.42U
+ PD=100.42U
* device instance $30 r0 *1 9.1,163.23 pfet
M$30 \$104 \$58 \$103 \$120 pfet L=0.5U W=100U AS=21P AD=21P PS=100.42U
+ PD=100.42U
* device instance $31 r0 *1 10.02,163.23 pfet
M$31 \$105 \$59 \$104 \$120 pfet L=0.5U W=100U AS=21P AD=21P PS=100.42U
+ PD=100.42U
* device instance $32 r0 *1 10.94,163.23 pfet
M$32 \$106 \$60 \$105 \$120 pfet L=0.5U W=100U AS=21P AD=21P PS=100.42U
+ PD=100.42U
* device instance $33 r0 *1 11.86,163.23 pfet
M$33 \$107 \$61 \$106 \$120 pfet L=0.5U W=100U AS=21P AD=21P PS=100.42U
+ PD=100.42U
* device instance $34 r0 *1 12.78,163.23 pfet
M$34 \$108 \$63 \$107 \$120 pfet L=0.5U W=100U AS=21P AD=21P PS=100.42U
+ PD=100.42U
* device instance $35 r0 *1 13.7,163.23 pfet
M$35 \$109 \$65 \$108 \$120 pfet L=0.5U W=100U AS=21P AD=21P PS=100.42U
+ PD=100.42U
* device instance $36 r0 *1 14.62,163.23 pfet
M$36 \$110 \$66 \$109 \$120 pfet L=0.5U W=100U AS=21P AD=21P PS=100.42U
+ PD=100.42U
* device instance $37 r0 *1 15.54,163.23 pfet
M$37 \$111 \$68 \$110 \$120 pfet L=0.5U W=100U AS=21P AD=21P PS=100.42U
+ PD=100.42U
* device instance $38 r0 *1 16.46,163.23 pfet
M$38 \$112 \$69 \$111 \$120 pfet L=0.5U W=100U AS=21P AD=21P PS=100.42U
+ PD=100.42U
* device instance $39 r0 *1 17.38,163.23 pfet
M$39 \$113 \$70 \$112 \$120 pfet L=0.5U W=100U AS=21P AD=21P PS=100.42U
+ PD=100.42U
* device instance $40 r0 *1 18.3,163.23 pfet
M$40 \$114 \$71 \$113 \$120 pfet L=0.5U W=100U AS=21P AD=21P PS=100.42U
+ PD=100.42U
* device instance $41 r0 *1 19.22,163.23 pfet
M$41 \$115 \$72 \$114 \$120 pfet L=0.5U W=100U AS=21P AD=21P PS=100.42U
+ PD=100.42U
* device instance $42 r0 *1 20.14,163.23 pfet
M$42 \$116 \$73 \$115 \$120 pfet L=0.5U W=100U AS=21P AD=21P PS=100.42U
+ PD=100.42U
* device instance $43 r0 *1 21.06,163.23 pfet
M$43 \$117 \$75 \$116 \$120 pfet L=0.5U W=100U AS=21P AD=21P PS=100.42U
+ PD=100.42U
* device instance $44 r0 *1 21.98,163.23 pfet
M$44 \$118 \$77 \$117 \$120 pfet L=0.5U W=100U AS=21P AD=21P PS=100.42U
+ PD=100.42U
* device instance $45 r0 *1 22.9,163.23 pfet
M$45 \$119 \$78 \$118 \$120 pfet L=0.5U W=100U AS=21P AD=42P PS=100.42U
+ PD=200.84U
* device instance $46 r0 *1 750.42,0.21 res_high_po
R$46 \$1 \$2 vsubs 1160477.00515 res_high_po
* device instance $47 r0 *1 271.76,20.63 res_xhigh_po
R$47 \$7 \$8 vsubs 857142.857143 res_xhigh_po
* device instance $48 r0 *1 453.1,20.63 res_xhigh_po
R$48 \$9 \$10 vsubs 857142.857143 res_xhigh_po
* device instance $49 r0 *1 634.44,20.63 res_xhigh_po
R$49 \$11 \$12 vsubs 857142.857143 res_xhigh_po
.ENDS ldo_core
