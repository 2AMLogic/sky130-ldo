* Mechanically translated LVS reference netlist for `ldo_core`, generated by
* layout/bin/gen-ldo-reference-netlist.py from design/ldo_3v3in_1v8out.sch's
* own xschem netlist (issue #17). MOS model names translated to `klt extract`'s
* generic nfet/pfet classes; resistor model names already match flavor-specific
* classes. Capacitors are dropped (no klt gen capacitor generator exists --
* see layout/ldo-core/floorplan.md's Known gap). Regenerate rather than hand-edit.
.SUBCKT ldo_core VOUT VREF EN VIN
R_BIAS VIN NB 1160477.005147 res_high_po L=1500U W=0.42U A=630P P=3000.84U
M_BIASN1 NB NB BIAS_ENN 0 nfet L=1U W=4U
M_ENN BIAS_ENN EN 0 0 nfet L=0.5U W=10U
M_BIASN2 BIASP NB BIAS_ENN 0 nfet L=1U W=4U
M_BIASP1 BIASP BIASP VIN VIN pfet L=1U W=10U
M_ENP2 BIASP EN VIN VIN pfet L=0.5U W=10U
M_TAIL EA_TAIL BIASP VIN VIN pfet L=2U W=40U
M_IN1 EA_D1 FB EA_TAIL VIN pfet L=2U W=10U
M_IN2 EA_D2 VREF EA_TAIL VIN pfet L=2U W=10U
M_MIR1 EA_D1 EA_D1 AMP_ENN 0 nfet L=4U W=10U
M_MIR2 EA_OUT EA_D1 AMP_ENN 0 nfet L=4U W=10U
M_ENN2 AMP_ENN EN 0 0 nfet L=0.5U W=10U
M_ENP EA_OUT EN VIN VIN pfet L=0.5U W=10U
M_MIR3 EA_D2 EA_D2 AMP_ENN 0 nfet L=4U W=10U
M_MIR4 PB EA_D2 AMP_ENN 0 nfet L=4U W=10U
M_MIRP1 PB PB VIN VIN pfet L=4U W=20U
M_MIRP2 EA_OUT PB VIN VIN pfet L=4U W=20U
M_ENP5 PB EN VIN VIN pfet L=0.5U W=2U
M_PASS VOUT EA_OUT VIN VIN pfet L=0.5U W=2500U
R_CZ EA_CZ EA_OUT 247619.047619 res_xhigh_po L=52U W=0.42U A=21.84P P=104.84U
R_FB_A VOUT FB 857142.857143 res_xhigh_po L=180U W=0.42U A=75.6P P=360.84U
R_FB_B FB N_FBB 857142.857143 res_xhigh_po L=180U W=0.42U A=75.6P P=360.84U
R_FB_C N_FBB 0 857142.857143 res_xhigh_po L=180U W=0.42U A=75.6P P=360.84U
M_SENSE CL_SNS EA_OUT VIN VIN pfet L=0.5U W=0.42U
M_CLN1 CL_SNS CL_SNS AMP_ENN 0 nfet L=1U W=20U
M_CLN2 CL_CMP CL_SNS AMP_ENN 0 nfet L=1U W=1.6U
M_CLP CL_CMP BIASP VIN VIN pfet L=1U W=10U
M_CLIM EA_OUT CL_CMP VIN VIN pfet L=0.5U W=20U
M_ENP3 CL_CMP EN VIN VIN pfet L=0.5U W=2U
M_INVP ENB EN VIN VIN pfet L=0.5U W=2U
M_INVN ENB EN 0 0 nfet L=0.5U W=1U
M_SSDIS SS ENB 0 0 nfet L=0.5U W=2U
M_SSCHG SS BIASP VIN VIN pfet L=8U W=1U
M_IN2S EA_D2 SS EA_TAIL VIN pfet L=2U W=10U
M_TSPS TS_SNS BIASP VIN VIN pfet L=1U W=1.25U
M_TSD1 TS_SNS TS_SNS TS_MID 0 nfet L=4U W=80U
M_TSD2 TS_MID TS_MID AMP_ENN 0 nfet L=4U W=80U
M_TSPR TS_REF BIASP VIN VIN pfet L=1U W=7U
M_TSR1 TS_REF TS_REF AMP_ENN 0 nfet L=2U W=0.42U
M_TCTAIL TC_TAIL NB AMP_ENN 0 nfet L=1U W=1U
M_TCN1 TC_D1 TS_SNS TC_TAIL 0 nfet L=2U W=10U
M_TCN2 TS_CMP TS_REF TC_TAIL 0 nfet L=2U W=10U
M_TCP1 TC_D1 TC_D1 VIN VIN pfet L=2U W=10U
M_TCP2 TS_CMP TC_D1 VIN VIN pfet L=2U W=10U
M_TSHUT EA_OUT TS_CMP VIN VIN pfet L=0.5U W=20U
M_TSHYSB TS_HYS BIASP VIN VIN pfet L=2U W=4.5U
M_TSHYS TS_REF TS_CMP TS_HYS VIN pfet L=0.5U W=2U
M_ENP4 TS_CMP EN VIN VIN pfet L=0.5U W=2U
.ENDS ldo_core
