* LVS reference for `cap_rail_demo` (issue #254), generated by gen-cap-rail-demo.py
* from design/ldo_3v3in_1v8out.sch's own xschem netlist. Each schematic capacitor is
* drawn as stacked MiM units (cap_mim_m3_1 + cap_mim_m3_2 over the same footprint, in
* parallel), so it is stated here as one element per MiM class carrying half the
* schematic value. Values are the SCHEMATIC's, not the drawn geometry's.
.SUBCKT cap_rail_demo VOUT VIN EA_CZ CL_CMP SS TS_CMP
C_COMP_M3 VOUT EA_CZ 7.500000e-11 sky130_fd_pr__model__cap_mim
C_COMP_M4 VOUT EA_CZ 7.500000e-11 sky130_fd_pr__model__cap_mim_m4
C_SS_M3 SS 0 5.000000e-12 sky130_fd_pr__model__cap_mim
C_SS_M4 SS 0 5.000000e-12 sky130_fd_pr__model__cap_mim_m4
C_CL_M3 VIN CL_CMP 5.000000e-13 sky130_fd_pr__model__cap_mim
C_CL_M4 VIN CL_CMP 5.000000e-13 sky130_fd_pr__model__cap_mim_m4
C_TS_M3 VIN TS_CMP 5.000000e-13 sky130_fd_pr__model__cap_mim
C_TS_M4 VIN TS_CMP 5.000000e-13 sky130_fd_pr__model__cap_mim_m4
.ENDS cap_rail_demo
