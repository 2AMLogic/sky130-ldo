* extracted by klt extract --deck sky130

* cell cap_rail_demo
* pin CL_CMP
* pin EA_CZ
* pin SS
* pin TS_CMP
* pin VIN
* pin VOUT
.SUBCKT cap_rail_demo CL_CMP EA_CZ SS TS_CMP VIN VOUT
* device instance $1 r0 *1 19.24,15.84 sky130_fd_pr__model__cap_mim
C$1 VOUT EA_CZ 1.6668816e-12
* device instance $2 r0 *1 49.12,15.84 sky130_fd_pr__model__cap_mim
C$2 VOUT EA_CZ 1.6668816e-12
* device instance $3 r0 *1 79,15.84 sky130_fd_pr__model__cap_mim
C$3 VOUT EA_CZ 1.6668816e-12
* device instance $4 r0 *1 108.88,15.84 sky130_fd_pr__model__cap_mim
C$4 VOUT EA_CZ 1.6668816e-12
* device instance $5 r0 *1 138.76,15.84 sky130_fd_pr__model__cap_mim
C$5 VOUT EA_CZ 1.6668816e-12
* device instance $6 r0 *1 168.64,15.84 sky130_fd_pr__model__cap_mim
C$6 VOUT EA_CZ 1.6668816e-12
* device instance $7 r0 *1 198.52,15.84 sky130_fd_pr__model__cap_mim
C$7 VOUT EA_CZ 1.6668816e-12
* device instance $8 r0 *1 228.4,15.84 sky130_fd_pr__model__cap_mim
C$8 VOUT EA_CZ 1.6668816e-12
* device instance $9 r0 *1 258.28,15.84 sky130_fd_pr__model__cap_mim
C$9 VOUT EA_CZ 1.6668816e-12
* device instance $10 r0 *1 19.24,45.72 sky130_fd_pr__model__cap_mim
C$10 VOUT EA_CZ 1.6668816e-12
* device instance $11 r0 *1 49.12,45.72 sky130_fd_pr__model__cap_mim
C$11 VOUT EA_CZ 1.6668816e-12
* device instance $12 r0 *1 79,45.72 sky130_fd_pr__model__cap_mim
C$12 VOUT EA_CZ 1.6668816e-12
* device instance $13 r0 *1 108.88,45.72 sky130_fd_pr__model__cap_mim
C$13 VOUT EA_CZ 1.6668816e-12
* device instance $14 r0 *1 138.76,45.72 sky130_fd_pr__model__cap_mim
C$14 VOUT EA_CZ 1.6668816e-12
* device instance $15 r0 *1 168.64,45.72 sky130_fd_pr__model__cap_mim
C$15 VOUT EA_CZ 1.6668816e-12
* device instance $16 r0 *1 198.52,45.72 sky130_fd_pr__model__cap_mim
C$16 VOUT EA_CZ 1.6668816e-12
* device instance $17 r0 *1 228.4,45.72 sky130_fd_pr__model__cap_mim
C$17 VOUT EA_CZ 1.6668816e-12
* device instance $18 r0 *1 258.28,45.72 sky130_fd_pr__model__cap_mim
C$18 VOUT EA_CZ 1.6668816e-12
* device instance $19 r0 *1 19.24,75.6 sky130_fd_pr__model__cap_mim
C$19 VOUT EA_CZ 1.6668816e-12
* device instance $20 r0 *1 49.12,75.6 sky130_fd_pr__model__cap_mim
C$20 VOUT EA_CZ 1.6668816e-12
* device instance $21 r0 *1 79,75.6 sky130_fd_pr__model__cap_mim
C$21 VOUT EA_CZ 1.6668816e-12
* device instance $22 r0 *1 108.88,75.6 sky130_fd_pr__model__cap_mim
C$22 VOUT EA_CZ 1.6668816e-12
* device instance $23 r0 *1 138.76,75.6 sky130_fd_pr__model__cap_mim
C$23 VOUT EA_CZ 1.6668816e-12
* device instance $24 r0 *1 168.64,75.6 sky130_fd_pr__model__cap_mim
C$24 VOUT EA_CZ 1.6668816e-12
* device instance $25 r0 *1 198.52,75.6 sky130_fd_pr__model__cap_mim
C$25 VOUT EA_CZ 1.6668816e-12
* device instance $26 r0 *1 228.4,75.6 sky130_fd_pr__model__cap_mim
C$26 VOUT EA_CZ 1.6668816e-12
* device instance $27 r0 *1 258.28,75.6 sky130_fd_pr__model__cap_mim
C$27 VOUT EA_CZ 1.6668816e-12
* device instance $28 r0 *1 19.24,105.48 sky130_fd_pr__model__cap_mim
C$28 VOUT EA_CZ 1.6668816e-12
* device instance $29 r0 *1 49.12,105.48 sky130_fd_pr__model__cap_mim
C$29 VOUT EA_CZ 1.6668816e-12
* device instance $30 r0 *1 79,105.48 sky130_fd_pr__model__cap_mim
C$30 VOUT EA_CZ 1.6668816e-12
* device instance $31 r0 *1 108.88,105.48 sky130_fd_pr__model__cap_mim
C$31 VOUT EA_CZ 1.6668816e-12
* device instance $32 r0 *1 138.76,105.48 sky130_fd_pr__model__cap_mim
C$32 VOUT EA_CZ 1.6668816e-12
* device instance $33 r0 *1 168.64,105.48 sky130_fd_pr__model__cap_mim
C$33 VOUT EA_CZ 1.6668816e-12
* device instance $34 r0 *1 198.52,105.48 sky130_fd_pr__model__cap_mim
C$34 VOUT EA_CZ 1.6668816e-12
* device instance $35 r0 *1 228.4,105.48 sky130_fd_pr__model__cap_mim
C$35 VOUT EA_CZ 1.6668816e-12
* device instance $36 r0 *1 258.28,105.48 sky130_fd_pr__model__cap_mim
C$36 VOUT EA_CZ 1.6668816e-12
* device instance $37 r0 *1 19.24,135.36 sky130_fd_pr__model__cap_mim
C$37 VOUT EA_CZ 1.6668816e-12
* device instance $38 r0 *1 49.12,135.36 sky130_fd_pr__model__cap_mim
C$38 VOUT EA_CZ 1.6668816e-12
* device instance $39 r0 *1 79,135.36 sky130_fd_pr__model__cap_mim
C$39 VOUT EA_CZ 1.6668816e-12
* device instance $40 r0 *1 108.88,135.36 sky130_fd_pr__model__cap_mim
C$40 VOUT EA_CZ 1.6668816e-12
* device instance $41 r0 *1 138.76,135.36 sky130_fd_pr__model__cap_mim
C$41 VOUT EA_CZ 1.6668816e-12
* device instance $42 r0 *1 168.64,135.36 sky130_fd_pr__model__cap_mim
C$42 VOUT EA_CZ 1.6668816e-12
* device instance $43 r0 *1 198.52,135.36 sky130_fd_pr__model__cap_mim
C$43 VOUT EA_CZ 1.6668816e-12
* device instance $44 r0 *1 228.4,135.36 sky130_fd_pr__model__cap_mim
C$44 VOUT EA_CZ 1.6668816e-12
* device instance $45 r0 *1 258.28,135.36 sky130_fd_pr__model__cap_mim
C$45 VOUT EA_CZ 1.6668816e-12
* device instance $46 r0 *1 374.865,13.905 sky130_fd_pr__model__cap_mim
C$46 0 SS 1.2499278e-12
* device instance $47 r0 *1 400.875,13.905 sky130_fd_pr__model__cap_mim
C$47 0 SS 1.2499278e-12
* device instance $48 r0 *1 374.865,39.915 sky130_fd_pr__model__cap_mim
C$48 0 SS 1.2499278e-12
* device instance $49 r0 *1 400.875,39.915 sky130_fd_pr__model__cap_mim
C$49 0 SS 1.2499278e-12
* device instance $50 r0 *1 12.712,168.937 sky130_fd_pr__model__cap_mim
C$50 VIN CL_CMP 5.0015625e-13
* device instance $51 r0 *1 38.737,168.937 sky130_fd_pr__model__cap_mim
C$51 VIN TS_CMP 5.0015625e-13
* device instance $52 r0 *1 19.24,15.84 sky130_fd_pr__model__cap_mim_m4
C$52 EA_CZ VOUT 1.6668816e-12
* device instance $53 r0 *1 49.12,15.84 sky130_fd_pr__model__cap_mim_m4
C$53 EA_CZ VOUT 1.6668816e-12
* device instance $54 r0 *1 79,15.84 sky130_fd_pr__model__cap_mim_m4
C$54 EA_CZ VOUT 1.6668816e-12
* device instance $55 r0 *1 108.88,15.84 sky130_fd_pr__model__cap_mim_m4
C$55 EA_CZ VOUT 1.6668816e-12
* device instance $56 r0 *1 138.76,15.84 sky130_fd_pr__model__cap_mim_m4
C$56 EA_CZ VOUT 1.6668816e-12
* device instance $57 r0 *1 168.64,15.84 sky130_fd_pr__model__cap_mim_m4
C$57 EA_CZ VOUT 1.6668816e-12
* device instance $58 r0 *1 198.52,15.84 sky130_fd_pr__model__cap_mim_m4
C$58 EA_CZ VOUT 1.6668816e-12
* device instance $59 r0 *1 228.4,15.84 sky130_fd_pr__model__cap_mim_m4
C$59 EA_CZ VOUT 1.6668816e-12
* device instance $60 r0 *1 258.28,15.84 sky130_fd_pr__model__cap_mim_m4
C$60 EA_CZ VOUT 1.6668816e-12
* device instance $61 r0 *1 19.24,45.72 sky130_fd_pr__model__cap_mim_m4
C$61 EA_CZ VOUT 1.6668816e-12
* device instance $62 r0 *1 49.12,45.72 sky130_fd_pr__model__cap_mim_m4
C$62 EA_CZ VOUT 1.6668816e-12
* device instance $63 r0 *1 79,45.72 sky130_fd_pr__model__cap_mim_m4
C$63 EA_CZ VOUT 1.6668816e-12
* device instance $64 r0 *1 108.88,45.72 sky130_fd_pr__model__cap_mim_m4
C$64 EA_CZ VOUT 1.6668816e-12
* device instance $65 r0 *1 138.76,45.72 sky130_fd_pr__model__cap_mim_m4
C$65 EA_CZ VOUT 1.6668816e-12
* device instance $66 r0 *1 168.64,45.72 sky130_fd_pr__model__cap_mim_m4
C$66 EA_CZ VOUT 1.6668816e-12
* device instance $67 r0 *1 198.52,45.72 sky130_fd_pr__model__cap_mim_m4
C$67 EA_CZ VOUT 1.6668816e-12
* device instance $68 r0 *1 228.4,45.72 sky130_fd_pr__model__cap_mim_m4
C$68 EA_CZ VOUT 1.6668816e-12
* device instance $69 r0 *1 258.28,45.72 sky130_fd_pr__model__cap_mim_m4
C$69 EA_CZ VOUT 1.6668816e-12
* device instance $70 r0 *1 19.24,75.6 sky130_fd_pr__model__cap_mim_m4
C$70 EA_CZ VOUT 1.6668816e-12
* device instance $71 r0 *1 49.12,75.6 sky130_fd_pr__model__cap_mim_m4
C$71 EA_CZ VOUT 1.6668816e-12
* device instance $72 r0 *1 79,75.6 sky130_fd_pr__model__cap_mim_m4
C$72 EA_CZ VOUT 1.6668816e-12
* device instance $73 r0 *1 108.88,75.6 sky130_fd_pr__model__cap_mim_m4
C$73 EA_CZ VOUT 1.6668816e-12
* device instance $74 r0 *1 138.76,75.6 sky130_fd_pr__model__cap_mim_m4
C$74 EA_CZ VOUT 1.6668816e-12
* device instance $75 r0 *1 168.64,75.6 sky130_fd_pr__model__cap_mim_m4
C$75 EA_CZ VOUT 1.6668816e-12
* device instance $76 r0 *1 198.52,75.6 sky130_fd_pr__model__cap_mim_m4
C$76 EA_CZ VOUT 1.6668816e-12
* device instance $77 r0 *1 228.4,75.6 sky130_fd_pr__model__cap_mim_m4
C$77 EA_CZ VOUT 1.6668816e-12
* device instance $78 r0 *1 258.28,75.6 sky130_fd_pr__model__cap_mim_m4
C$78 EA_CZ VOUT 1.6668816e-12
* device instance $79 r0 *1 19.24,105.48 sky130_fd_pr__model__cap_mim_m4
C$79 EA_CZ VOUT 1.6668816e-12
* device instance $80 r0 *1 49.12,105.48 sky130_fd_pr__model__cap_mim_m4
C$80 EA_CZ VOUT 1.6668816e-12
* device instance $81 r0 *1 79,105.48 sky130_fd_pr__model__cap_mim_m4
C$81 EA_CZ VOUT 1.6668816e-12
* device instance $82 r0 *1 108.88,105.48 sky130_fd_pr__model__cap_mim_m4
C$82 EA_CZ VOUT 1.6668816e-12
* device instance $83 r0 *1 138.76,105.48 sky130_fd_pr__model__cap_mim_m4
C$83 EA_CZ VOUT 1.6668816e-12
* device instance $84 r0 *1 168.64,105.48 sky130_fd_pr__model__cap_mim_m4
C$84 EA_CZ VOUT 1.6668816e-12
* device instance $85 r0 *1 198.52,105.48 sky130_fd_pr__model__cap_mim_m4
C$85 EA_CZ VOUT 1.6668816e-12
* device instance $86 r0 *1 228.4,105.48 sky130_fd_pr__model__cap_mim_m4
C$86 EA_CZ VOUT 1.6668816e-12
* device instance $87 r0 *1 258.28,105.48 sky130_fd_pr__model__cap_mim_m4
C$87 EA_CZ VOUT 1.6668816e-12
* device instance $88 r0 *1 19.24,135.36 sky130_fd_pr__model__cap_mim_m4
C$88 EA_CZ VOUT 1.6668816e-12
* device instance $89 r0 *1 49.12,135.36 sky130_fd_pr__model__cap_mim_m4
C$89 EA_CZ VOUT 1.6668816e-12
* device instance $90 r0 *1 79,135.36 sky130_fd_pr__model__cap_mim_m4
C$90 EA_CZ VOUT 1.6668816e-12
* device instance $91 r0 *1 108.88,135.36 sky130_fd_pr__model__cap_mim_m4
C$91 EA_CZ VOUT 1.6668816e-12
* device instance $92 r0 *1 138.76,135.36 sky130_fd_pr__model__cap_mim_m4
C$92 EA_CZ VOUT 1.6668816e-12
* device instance $93 r0 *1 168.64,135.36 sky130_fd_pr__model__cap_mim_m4
C$93 EA_CZ VOUT 1.6668816e-12
* device instance $94 r0 *1 198.52,135.36 sky130_fd_pr__model__cap_mim_m4
C$94 EA_CZ VOUT 1.6668816e-12
* device instance $95 r0 *1 228.4,135.36 sky130_fd_pr__model__cap_mim_m4
C$95 EA_CZ VOUT 1.6668816e-12
* device instance $96 r0 *1 258.28,135.36 sky130_fd_pr__model__cap_mim_m4
C$96 EA_CZ VOUT 1.6668816e-12
* device instance $97 r0 *1 374.865,13.905 sky130_fd_pr__model__cap_mim_m4
C$97 SS 0 1.2499278e-12
* device instance $98 r0 *1 400.875,13.905 sky130_fd_pr__model__cap_mim_m4
C$98 SS 0 1.2499278e-12
* device instance $99 r0 *1 374.865,39.915 sky130_fd_pr__model__cap_mim_m4
C$99 SS 0 1.2499278e-12
* device instance $100 r0 *1 400.875,39.915 sky130_fd_pr__model__cap_mim_m4
C$100 SS 0 1.2499278e-12
* device instance $101 r0 *1 12.712,168.937 sky130_fd_pr__model__cap_mim_m4
C$101 CL_CMP VIN 5.0015625e-13
* device instance $102 r0 *1 38.737,168.937 sky130_fd_pr__model__cap_mim_m4
C$102 TS_CMP VIN 5.0015625e-13
.ENDS cap_rail_demo
