* klt sim -- generated corner deck, do not edit
.lib /opt/pdk/sky130A/libs.tech/combined/sky130.lib.spice tt
.include /var/tmp/eda-job-klt-sim-c9f01fce5aef/inputs/netlist.cir
.temp 27.0
.meas ac vi_lvt_w5_l0p5_m2p30_f0 find vi(n_lvt_w5_l0p5_m2p30) at=1000
.meas ac vi_lvt_w5_l0p5_m2p30_f1 find vi(n_lvt_w5_l0p5_m2p30) at=178273
.meas ac vi_lvt_w5_l0p5_m2p20_f0 find vi(n_lvt_w5_l0p5_m2p20) at=1000
.meas ac vi_lvt_w5_l0p5_m2p20_f1 find vi(n_lvt_w5_l0p5_m2p20) at=178273
.meas ac vi_lvt_w5_l0p5_m2p10_f0 find vi(n_lvt_w5_l0p5_m2p10) at=1000
.meas ac vi_lvt_w5_l0p5_m2p10_f1 find vi(n_lvt_w5_l0p5_m2p10) at=178273
.meas ac vi_lvt_w5_l0p5_m2p00_f0 find vi(n_lvt_w5_l0p5_m2p00) at=1000
.meas ac vi_lvt_w5_l0p5_m2p00_f1 find vi(n_lvt_w5_l0p5_m2p00) at=178273
.meas ac vi_lvt_w5_l0p5_m1p90_f0 find vi(n_lvt_w5_l0p5_m1p90) at=1000
.meas ac vi_lvt_w5_l0p5_m1p90_f1 find vi(n_lvt_w5_l0p5_m1p90) at=178273
.meas ac vi_lvt_w5_l0p5_m1p80_f0 find vi(n_lvt_w5_l0p5_m1p80) at=1000
.meas ac vi_lvt_w5_l0p5_m1p80_f1 find vi(n_lvt_w5_l0p5_m1p80) at=178273
.meas ac vi_lvt_w5_l0p5_m1p70_f0 find vi(n_lvt_w5_l0p5_m1p70) at=1000
.meas ac vi_lvt_w5_l0p5_m1p70_f1 find vi(n_lvt_w5_l0p5_m1p70) at=178273
.meas ac vi_lvt_w5_l0p5_m1p60_f0 find vi(n_lvt_w5_l0p5_m1p60) at=1000
.meas ac vi_lvt_w5_l0p5_m1p60_f1 find vi(n_lvt_w5_l0p5_m1p60) at=178273
.meas ac vi_lvt_w5_l0p5_m1p50_f0 find vi(n_lvt_w5_l0p5_m1p50) at=1000
.meas ac vi_lvt_w5_l0p5_m1p50_f1 find vi(n_lvt_w5_l0p5_m1p50) at=178273
.meas ac vi_lvt_w5_l0p5_m1p40_f0 find vi(n_lvt_w5_l0p5_m1p40) at=1000
.meas ac vi_lvt_w5_l0p5_m1p40_f1 find vi(n_lvt_w5_l0p5_m1p40) at=178273
.meas ac vi_lvt_w5_l0p5_m1p30_f0 find vi(n_lvt_w5_l0p5_m1p30) at=1000
.meas ac vi_lvt_w5_l0p5_m1p30_f1 find vi(n_lvt_w5_l0p5_m1p30) at=178273
.meas ac vi_lvt_w5_l0p5_m1p20_f0 find vi(n_lvt_w5_l0p5_m1p20) at=1000
.meas ac vi_lvt_w5_l0p5_m1p20_f1 find vi(n_lvt_w5_l0p5_m1p20) at=178273
.meas ac vi_lvt_w5_l0p5_m1p10_f0 find vi(n_lvt_w5_l0p5_m1p10) at=1000
.meas ac vi_lvt_w5_l0p5_m1p10_f1 find vi(n_lvt_w5_l0p5_m1p10) at=178273
.meas ac vi_lvt_w5_l0p5_m1p00_f0 find vi(n_lvt_w5_l0p5_m1p00) at=1000
.meas ac vi_lvt_w5_l0p5_m1p00_f1 find vi(n_lvt_w5_l0p5_m1p00) at=178273
.meas ac vi_lvt_w5_l0p5_m0p90_f0 find vi(n_lvt_w5_l0p5_m0p90) at=1000
.meas ac vi_lvt_w5_l0p5_m0p90_f1 find vi(n_lvt_w5_l0p5_m0p90) at=178273
.meas ac vi_lvt_w5_l0p5_m0p80_f0 find vi(n_lvt_w5_l0p5_m0p80) at=1000
.meas ac vi_lvt_w5_l0p5_m0p80_f1 find vi(n_lvt_w5_l0p5_m0p80) at=178273
.meas ac vi_lvt_w5_l0p5_m0p70_f0 find vi(n_lvt_w5_l0p5_m0p70) at=1000
.meas ac vi_lvt_w5_l0p5_m0p70_f1 find vi(n_lvt_w5_l0p5_m0p70) at=178273
.meas ac vi_lvt_w5_l0p5_m0p60_f0 find vi(n_lvt_w5_l0p5_m0p60) at=1000
.meas ac vi_lvt_w5_l0p5_m0p60_f1 find vi(n_lvt_w5_l0p5_m0p60) at=178273
.meas ac vi_lvt_w5_l0p5_m0p50_f0 find vi(n_lvt_w5_l0p5_m0p50) at=1000
.meas ac vi_lvt_w5_l0p5_m0p50_f1 find vi(n_lvt_w5_l0p5_m0p50) at=178273
.meas ac vi_lvt_w5_l0p5_m0p40_f0 find vi(n_lvt_w5_l0p5_m0p40) at=1000
.meas ac vi_lvt_w5_l0p5_m0p40_f1 find vi(n_lvt_w5_l0p5_m0p40) at=178273
.meas ac vi_lvt_w5_l0p5_m0p30_f0 find vi(n_lvt_w5_l0p5_m0p30) at=1000
.meas ac vi_lvt_w5_l0p5_m0p30_f1 find vi(n_lvt_w5_l0p5_m0p30) at=178273
.meas ac vi_lvt_w5_l0p5_m0p20_f0 find vi(n_lvt_w5_l0p5_m0p20) at=1000
.meas ac vi_lvt_w5_l0p5_m0p20_f1 find vi(n_lvt_w5_l0p5_m0p20) at=178273
.meas ac vi_lvt_w5_l0p5_m0p10_f0 find vi(n_lvt_w5_l0p5_m0p10) at=1000
.meas ac vi_lvt_w5_l0p5_m0p10_f1 find vi(n_lvt_w5_l0p5_m0p10) at=178273
.meas ac vi_lvt_w5_l0p5_p0p00_f0 find vi(n_lvt_w5_l0p5_p0p00) at=1000
.meas ac vi_lvt_w5_l0p5_p0p00_f1 find vi(n_lvt_w5_l0p5_p0p00) at=178273
.meas ac vi_lvt_w5_l0p5_p0p10_f0 find vi(n_lvt_w5_l0p5_p0p10) at=1000
.meas ac vi_lvt_w5_l0p5_p0p10_f1 find vi(n_lvt_w5_l0p5_p0p10) at=178273
.meas ac vi_lvt_w5_l0p5_p0p20_f0 find vi(n_lvt_w5_l0p5_p0p20) at=1000
.meas ac vi_lvt_w5_l0p5_p0p20_f1 find vi(n_lvt_w5_l0p5_p0p20) at=178273
.meas ac vi_lvt_w5_l0p5_p0p30_f0 find vi(n_lvt_w5_l0p5_p0p30) at=1000
.meas ac vi_lvt_w5_l0p5_p0p30_f1 find vi(n_lvt_w5_l0p5_p0p30) at=178273
.meas ac vi_lvt_w5_l0p5_p0p40_f0 find vi(n_lvt_w5_l0p5_p0p40) at=1000
.meas ac vi_lvt_w5_l0p5_p0p40_f1 find vi(n_lvt_w5_l0p5_p0p40) at=178273
.meas ac vi_lvt_w5_l0p5_p0p50_f0 find vi(n_lvt_w5_l0p5_p0p50) at=1000
.meas ac vi_lvt_w5_l0p5_p0p50_f1 find vi(n_lvt_w5_l0p5_p0p50) at=178273
.meas ac vi_lvt_w5_l0p5_p0p60_f0 find vi(n_lvt_w5_l0p5_p0p60) at=1000
.meas ac vi_lvt_w5_l0p5_p0p60_f1 find vi(n_lvt_w5_l0p5_p0p60) at=178273
.meas ac vi_lvt_w5_l0p5_p0p70_f0 find vi(n_lvt_w5_l0p5_p0p70) at=1000
.meas ac vi_lvt_w5_l0p5_p0p70_f1 find vi(n_lvt_w5_l0p5_p0p70) at=178273
.meas ac vi_lvt_w5_l0p5_p0p80_f0 find vi(n_lvt_w5_l0p5_p0p80) at=1000
.meas ac vi_lvt_w5_l0p5_p0p80_f1 find vi(n_lvt_w5_l0p5_p0p80) at=178273
.meas ac vi_lvt_w5_l0p5_p0p90_f0 find vi(n_lvt_w5_l0p5_p0p90) at=1000
.meas ac vi_lvt_w5_l0p5_p0p90_f1 find vi(n_lvt_w5_l0p5_p0p90) at=178273
.meas ac vi_lvt_w5_l0p5_p1p00_f0 find vi(n_lvt_w5_l0p5_p1p00) at=1000
.meas ac vi_lvt_w5_l0p5_p1p00_f1 find vi(n_lvt_w5_l0p5_p1p00) at=178273
.meas ac vi_lvt_w5_l0p5_p1p10_f0 find vi(n_lvt_w5_l0p5_p1p10) at=1000
.meas ac vi_lvt_w5_l0p5_p1p10_f1 find vi(n_lvt_w5_l0p5_p1p10) at=178273
.meas ac vi_lvt_w5_l0p5_p1p20_f0 find vi(n_lvt_w5_l0p5_p1p20) at=1000
.meas ac vi_lvt_w5_l0p5_p1p20_f1 find vi(n_lvt_w5_l0p5_p1p20) at=178273
.meas ac vi_lvt_w5_l0p5_p1p30_f0 find vi(n_lvt_w5_l0p5_p1p30) at=1000
.meas ac vi_lvt_w5_l0p5_p1p30_f1 find vi(n_lvt_w5_l0p5_p1p30) at=178273
.meas ac vi_lvt_w5_l0p5_p1p40_f0 find vi(n_lvt_w5_l0p5_p1p40) at=1000
.meas ac vi_lvt_w5_l0p5_p1p40_f1 find vi(n_lvt_w5_l0p5_p1p40) at=178273
.meas ac vi_lvt_w5_l0p5_p1p50_f0 find vi(n_lvt_w5_l0p5_p1p50) at=1000
.meas ac vi_lvt_w5_l0p5_p1p50_f1 find vi(n_lvt_w5_l0p5_p1p50) at=178273
.meas ac vi_lvt_w5_l0p5_p1p60_f0 find vi(n_lvt_w5_l0p5_p1p60) at=1000
.meas ac vi_lvt_w5_l0p5_p1p60_f1 find vi(n_lvt_w5_l0p5_p1p60) at=178273
.meas ac vi_lvt_w5_l0p5_p1p70_f0 find vi(n_lvt_w5_l0p5_p1p70) at=1000
.meas ac vi_lvt_w5_l0p5_p1p70_f1 find vi(n_lvt_w5_l0p5_p1p70) at=178273
.meas ac vi_lvt_w5_l0p5_p1p80_f0 find vi(n_lvt_w5_l0p5_p1p80) at=1000
.meas ac vi_lvt_w5_l0p5_p1p80_f1 find vi(n_lvt_w5_l0p5_p1p80) at=178273
.meas ac vi_lvt_w5_l0p5_p1p90_f0 find vi(n_lvt_w5_l0p5_p1p90) at=1000
.meas ac vi_lvt_w5_l0p5_p1p90_f1 find vi(n_lvt_w5_l0p5_p1p90) at=178273
.meas ac vi_lvt_w5_l0p5_p2p00_f0 find vi(n_lvt_w5_l0p5_p2p00) at=1000
.meas ac vi_lvt_w5_l0p5_p2p00_f1 find vi(n_lvt_w5_l0p5_p2p00) at=178273
.meas ac vi_lvt_w5_l0p5_p2p10_f0 find vi(n_lvt_w5_l0p5_p2p10) at=1000
.meas ac vi_lvt_w5_l0p5_p2p10_f1 find vi(n_lvt_w5_l0p5_p2p10) at=178273
.meas ac vi_lvt_w5_l0p5_p2p20_f0 find vi(n_lvt_w5_l0p5_p2p20) at=1000
.meas ac vi_lvt_w5_l0p5_p2p20_f1 find vi(n_lvt_w5_l0p5_p2p20) at=178273
.meas ac vi_lvt_w5_l0p5_p2p30_f0 find vi(n_lvt_w5_l0p5_p2p30) at=1000
.meas ac vi_lvt_w5_l0p5_p2p30_f1 find vi(n_lvt_w5_l0p5_p2p30) at=178273
.meas ac vi_lvt_w10_l10_m2p30_f0 find vi(n_lvt_w10_l10_m2p30) at=1000
.meas ac vi_lvt_w10_l10_m2p30_f1 find vi(n_lvt_w10_l10_m2p30) at=178273
.meas ac vi_lvt_w10_l10_m2p20_f0 find vi(n_lvt_w10_l10_m2p20) at=1000
.meas ac vi_lvt_w10_l10_m2p20_f1 find vi(n_lvt_w10_l10_m2p20) at=178273
.meas ac vi_lvt_w10_l10_m2p10_f0 find vi(n_lvt_w10_l10_m2p10) at=1000
.meas ac vi_lvt_w10_l10_m2p10_f1 find vi(n_lvt_w10_l10_m2p10) at=178273
.meas ac vi_lvt_w10_l10_m2p00_f0 find vi(n_lvt_w10_l10_m2p00) at=1000
.meas ac vi_lvt_w10_l10_m2p00_f1 find vi(n_lvt_w10_l10_m2p00) at=178273
.meas ac vi_lvt_w10_l10_m1p90_f0 find vi(n_lvt_w10_l10_m1p90) at=1000
.meas ac vi_lvt_w10_l10_m1p90_f1 find vi(n_lvt_w10_l10_m1p90) at=178273
.meas ac vi_lvt_w10_l10_m1p80_f0 find vi(n_lvt_w10_l10_m1p80) at=1000
.meas ac vi_lvt_w10_l10_m1p80_f1 find vi(n_lvt_w10_l10_m1p80) at=178273
.meas ac vi_lvt_w10_l10_m1p70_f0 find vi(n_lvt_w10_l10_m1p70) at=1000
.meas ac vi_lvt_w10_l10_m1p70_f1 find vi(n_lvt_w10_l10_m1p70) at=178273
.meas ac vi_lvt_w10_l10_m1p60_f0 find vi(n_lvt_w10_l10_m1p60) at=1000
.meas ac vi_lvt_w10_l10_m1p60_f1 find vi(n_lvt_w10_l10_m1p60) at=178273
.meas ac vi_lvt_w10_l10_m1p50_f0 find vi(n_lvt_w10_l10_m1p50) at=1000
.meas ac vi_lvt_w10_l10_m1p50_f1 find vi(n_lvt_w10_l10_m1p50) at=178273
.meas ac vi_lvt_w10_l10_m1p40_f0 find vi(n_lvt_w10_l10_m1p40) at=1000
.meas ac vi_lvt_w10_l10_m1p40_f1 find vi(n_lvt_w10_l10_m1p40) at=178273
.meas ac vi_lvt_w10_l10_m1p30_f0 find vi(n_lvt_w10_l10_m1p30) at=1000
.meas ac vi_lvt_w10_l10_m1p30_f1 find vi(n_lvt_w10_l10_m1p30) at=178273
.meas ac vi_lvt_w10_l10_m1p20_f0 find vi(n_lvt_w10_l10_m1p20) at=1000
.meas ac vi_lvt_w10_l10_m1p20_f1 find vi(n_lvt_w10_l10_m1p20) at=178273
.meas ac vi_lvt_w10_l10_m1p10_f0 find vi(n_lvt_w10_l10_m1p10) at=1000
.meas ac vi_lvt_w10_l10_m1p10_f1 find vi(n_lvt_w10_l10_m1p10) at=178273
.meas ac vi_lvt_w10_l10_m1p00_f0 find vi(n_lvt_w10_l10_m1p00) at=1000
.meas ac vi_lvt_w10_l10_m1p00_f1 find vi(n_lvt_w10_l10_m1p00) at=178273
.meas ac vi_lvt_w10_l10_m0p90_f0 find vi(n_lvt_w10_l10_m0p90) at=1000
.meas ac vi_lvt_w10_l10_m0p90_f1 find vi(n_lvt_w10_l10_m0p90) at=178273
.meas ac vi_lvt_w10_l10_m0p80_f0 find vi(n_lvt_w10_l10_m0p80) at=1000
.meas ac vi_lvt_w10_l10_m0p80_f1 find vi(n_lvt_w10_l10_m0p80) at=178273
.meas ac vi_lvt_w10_l10_m0p70_f0 find vi(n_lvt_w10_l10_m0p70) at=1000
.meas ac vi_lvt_w10_l10_m0p70_f1 find vi(n_lvt_w10_l10_m0p70) at=178273
.meas ac vi_lvt_w10_l10_m0p60_f0 find vi(n_lvt_w10_l10_m0p60) at=1000
.meas ac vi_lvt_w10_l10_m0p60_f1 find vi(n_lvt_w10_l10_m0p60) at=178273
.meas ac vi_lvt_w10_l10_m0p50_f0 find vi(n_lvt_w10_l10_m0p50) at=1000
.meas ac vi_lvt_w10_l10_m0p50_f1 find vi(n_lvt_w10_l10_m0p50) at=178273
.meas ac vi_lvt_w10_l10_m0p40_f0 find vi(n_lvt_w10_l10_m0p40) at=1000
.meas ac vi_lvt_w10_l10_m0p40_f1 find vi(n_lvt_w10_l10_m0p40) at=178273
.meas ac vi_lvt_w10_l10_m0p30_f0 find vi(n_lvt_w10_l10_m0p30) at=1000
.meas ac vi_lvt_w10_l10_m0p30_f1 find vi(n_lvt_w10_l10_m0p30) at=178273
.meas ac vi_lvt_w10_l10_m0p20_f0 find vi(n_lvt_w10_l10_m0p20) at=1000
.meas ac vi_lvt_w10_l10_m0p20_f1 find vi(n_lvt_w10_l10_m0p20) at=178273
.meas ac vi_lvt_w10_l10_m0p10_f0 find vi(n_lvt_w10_l10_m0p10) at=1000
.meas ac vi_lvt_w10_l10_m0p10_f1 find vi(n_lvt_w10_l10_m0p10) at=178273
.meas ac vi_lvt_w10_l10_p0p00_f0 find vi(n_lvt_w10_l10_p0p00) at=1000
.meas ac vi_lvt_w10_l10_p0p00_f1 find vi(n_lvt_w10_l10_p0p00) at=178273
.meas ac vi_lvt_w10_l10_p0p10_f0 find vi(n_lvt_w10_l10_p0p10) at=1000
.meas ac vi_lvt_w10_l10_p0p10_f1 find vi(n_lvt_w10_l10_p0p10) at=178273
.meas ac vi_lvt_w10_l10_p0p20_f0 find vi(n_lvt_w10_l10_p0p20) at=1000
.meas ac vi_lvt_w10_l10_p0p20_f1 find vi(n_lvt_w10_l10_p0p20) at=178273
.meas ac vi_lvt_w10_l10_p0p30_f0 find vi(n_lvt_w10_l10_p0p30) at=1000
.meas ac vi_lvt_w10_l10_p0p30_f1 find vi(n_lvt_w10_l10_p0p30) at=178273
.meas ac vi_lvt_w10_l10_p0p40_f0 find vi(n_lvt_w10_l10_p0p40) at=1000
.meas ac vi_lvt_w10_l10_p0p40_f1 find vi(n_lvt_w10_l10_p0p40) at=178273
.meas ac vi_lvt_w10_l10_p0p50_f0 find vi(n_lvt_w10_l10_p0p50) at=1000
.meas ac vi_lvt_w10_l10_p0p50_f1 find vi(n_lvt_w10_l10_p0p50) at=178273
.meas ac vi_lvt_w10_l10_p0p60_f0 find vi(n_lvt_w10_l10_p0p60) at=1000
.meas ac vi_lvt_w10_l10_p0p60_f1 find vi(n_lvt_w10_l10_p0p60) at=178273
.meas ac vi_lvt_w10_l10_p0p70_f0 find vi(n_lvt_w10_l10_p0p70) at=1000
.meas ac vi_lvt_w10_l10_p0p70_f1 find vi(n_lvt_w10_l10_p0p70) at=178273
.meas ac vi_lvt_w10_l10_p0p80_f0 find vi(n_lvt_w10_l10_p0p80) at=1000
.meas ac vi_lvt_w10_l10_p0p80_f1 find vi(n_lvt_w10_l10_p0p80) at=178273
.meas ac vi_lvt_w10_l10_p0p90_f0 find vi(n_lvt_w10_l10_p0p90) at=1000
.meas ac vi_lvt_w10_l10_p0p90_f1 find vi(n_lvt_w10_l10_p0p90) at=178273
.meas ac vi_lvt_w10_l10_p1p00_f0 find vi(n_lvt_w10_l10_p1p00) at=1000
.meas ac vi_lvt_w10_l10_p1p00_f1 find vi(n_lvt_w10_l10_p1p00) at=178273
.meas ac vi_lvt_w10_l10_p1p10_f0 find vi(n_lvt_w10_l10_p1p10) at=1000
.meas ac vi_lvt_w10_l10_p1p10_f1 find vi(n_lvt_w10_l10_p1p10) at=178273
.meas ac vi_lvt_w10_l10_p1p20_f0 find vi(n_lvt_w10_l10_p1p20) at=1000
.meas ac vi_lvt_w10_l10_p1p20_f1 find vi(n_lvt_w10_l10_p1p20) at=178273
.meas ac vi_lvt_w10_l10_p1p30_f0 find vi(n_lvt_w10_l10_p1p30) at=1000
.meas ac vi_lvt_w10_l10_p1p30_f1 find vi(n_lvt_w10_l10_p1p30) at=178273
.meas ac vi_lvt_w10_l10_p1p40_f0 find vi(n_lvt_w10_l10_p1p40) at=1000
.meas ac vi_lvt_w10_l10_p1p40_f1 find vi(n_lvt_w10_l10_p1p40) at=178273
.meas ac vi_lvt_w10_l10_p1p50_f0 find vi(n_lvt_w10_l10_p1p50) at=1000
.meas ac vi_lvt_w10_l10_p1p50_f1 find vi(n_lvt_w10_l10_p1p50) at=178273
.meas ac vi_lvt_w10_l10_p1p60_f0 find vi(n_lvt_w10_l10_p1p60) at=1000
.meas ac vi_lvt_w10_l10_p1p60_f1 find vi(n_lvt_w10_l10_p1p60) at=178273
.meas ac vi_lvt_w10_l10_p1p70_f0 find vi(n_lvt_w10_l10_p1p70) at=1000
.meas ac vi_lvt_w10_l10_p1p70_f1 find vi(n_lvt_w10_l10_p1p70) at=178273
.meas ac vi_lvt_w10_l10_p1p80_f0 find vi(n_lvt_w10_l10_p1p80) at=1000
.meas ac vi_lvt_w10_l10_p1p80_f1 find vi(n_lvt_w10_l10_p1p80) at=178273
.meas ac vi_lvt_w10_l10_p1p90_f0 find vi(n_lvt_w10_l10_p1p90) at=1000
.meas ac vi_lvt_w10_l10_p1p90_f1 find vi(n_lvt_w10_l10_p1p90) at=178273
.meas ac vi_lvt_w10_l10_p2p00_f0 find vi(n_lvt_w10_l10_p2p00) at=1000
.meas ac vi_lvt_w10_l10_p2p00_f1 find vi(n_lvt_w10_l10_p2p00) at=178273
.meas ac vi_lvt_w10_l10_p2p10_f0 find vi(n_lvt_w10_l10_p2p10) at=1000
.meas ac vi_lvt_w10_l10_p2p10_f1 find vi(n_lvt_w10_l10_p2p10) at=178273
.meas ac vi_lvt_w10_l10_p2p20_f0 find vi(n_lvt_w10_l10_p2p20) at=1000
.meas ac vi_lvt_w10_l10_p2p20_f1 find vi(n_lvt_w10_l10_p2p20) at=178273
.meas ac vi_lvt_w10_l10_p2p30_f0 find vi(n_lvt_w10_l10_p2p30) at=1000
.meas ac vi_lvt_w10_l10_p2p30_f1 find vi(n_lvt_w10_l10_p2p30) at=178273
.meas ac vi_hvt_w5_l0p5_m2p30_f0 find vi(n_hvt_w5_l0p5_m2p30) at=1000
.meas ac vi_hvt_w5_l0p5_m2p30_f1 find vi(n_hvt_w5_l0p5_m2p30) at=178273
.meas ac vi_hvt_w5_l0p5_m2p20_f0 find vi(n_hvt_w5_l0p5_m2p20) at=1000
.meas ac vi_hvt_w5_l0p5_m2p20_f1 find vi(n_hvt_w5_l0p5_m2p20) at=178273
.meas ac vi_hvt_w5_l0p5_m2p10_f0 find vi(n_hvt_w5_l0p5_m2p10) at=1000
.meas ac vi_hvt_w5_l0p5_m2p10_f1 find vi(n_hvt_w5_l0p5_m2p10) at=178273
.meas ac vi_hvt_w5_l0p5_m2p00_f0 find vi(n_hvt_w5_l0p5_m2p00) at=1000
.meas ac vi_hvt_w5_l0p5_m2p00_f1 find vi(n_hvt_w5_l0p5_m2p00) at=178273
.meas ac vi_hvt_w5_l0p5_m1p90_f0 find vi(n_hvt_w5_l0p5_m1p90) at=1000
.meas ac vi_hvt_w5_l0p5_m1p90_f1 find vi(n_hvt_w5_l0p5_m1p90) at=178273
.meas ac vi_hvt_w5_l0p5_m1p80_f0 find vi(n_hvt_w5_l0p5_m1p80) at=1000
.meas ac vi_hvt_w5_l0p5_m1p80_f1 find vi(n_hvt_w5_l0p5_m1p80) at=178273
.meas ac vi_hvt_w5_l0p5_m1p70_f0 find vi(n_hvt_w5_l0p5_m1p70) at=1000
.meas ac vi_hvt_w5_l0p5_m1p70_f1 find vi(n_hvt_w5_l0p5_m1p70) at=178273
.meas ac vi_hvt_w5_l0p5_m1p60_f0 find vi(n_hvt_w5_l0p5_m1p60) at=1000
.meas ac vi_hvt_w5_l0p5_m1p60_f1 find vi(n_hvt_w5_l0p5_m1p60) at=178273
.meas ac vi_hvt_w5_l0p5_m1p50_f0 find vi(n_hvt_w5_l0p5_m1p50) at=1000
.meas ac vi_hvt_w5_l0p5_m1p50_f1 find vi(n_hvt_w5_l0p5_m1p50) at=178273
.meas ac vi_hvt_w5_l0p5_m1p40_f0 find vi(n_hvt_w5_l0p5_m1p40) at=1000
.meas ac vi_hvt_w5_l0p5_m1p40_f1 find vi(n_hvt_w5_l0p5_m1p40) at=178273
.meas ac vi_hvt_w5_l0p5_m1p30_f0 find vi(n_hvt_w5_l0p5_m1p30) at=1000
.meas ac vi_hvt_w5_l0p5_m1p30_f1 find vi(n_hvt_w5_l0p5_m1p30) at=178273
.meas ac vi_hvt_w5_l0p5_m1p20_f0 find vi(n_hvt_w5_l0p5_m1p20) at=1000
.meas ac vi_hvt_w5_l0p5_m1p20_f1 find vi(n_hvt_w5_l0p5_m1p20) at=178273
.meas ac vi_hvt_w5_l0p5_m1p10_f0 find vi(n_hvt_w5_l0p5_m1p10) at=1000
.meas ac vi_hvt_w5_l0p5_m1p10_f1 find vi(n_hvt_w5_l0p5_m1p10) at=178273
.meas ac vi_hvt_w5_l0p5_m1p00_f0 find vi(n_hvt_w5_l0p5_m1p00) at=1000
.meas ac vi_hvt_w5_l0p5_m1p00_f1 find vi(n_hvt_w5_l0p5_m1p00) at=178273
.meas ac vi_hvt_w5_l0p5_m0p90_f0 find vi(n_hvt_w5_l0p5_m0p90) at=1000
.meas ac vi_hvt_w5_l0p5_m0p90_f1 find vi(n_hvt_w5_l0p5_m0p90) at=178273
.meas ac vi_hvt_w5_l0p5_m0p80_f0 find vi(n_hvt_w5_l0p5_m0p80) at=1000
.meas ac vi_hvt_w5_l0p5_m0p80_f1 find vi(n_hvt_w5_l0p5_m0p80) at=178273
.meas ac vi_hvt_w5_l0p5_m0p70_f0 find vi(n_hvt_w5_l0p5_m0p70) at=1000
.meas ac vi_hvt_w5_l0p5_m0p70_f1 find vi(n_hvt_w5_l0p5_m0p70) at=178273
.meas ac vi_hvt_w5_l0p5_m0p60_f0 find vi(n_hvt_w5_l0p5_m0p60) at=1000
.meas ac vi_hvt_w5_l0p5_m0p60_f1 find vi(n_hvt_w5_l0p5_m0p60) at=178273
.meas ac vi_hvt_w5_l0p5_m0p50_f0 find vi(n_hvt_w5_l0p5_m0p50) at=1000
.meas ac vi_hvt_w5_l0p5_m0p50_f1 find vi(n_hvt_w5_l0p5_m0p50) at=178273
.meas ac vi_hvt_w5_l0p5_m0p40_f0 find vi(n_hvt_w5_l0p5_m0p40) at=1000
.meas ac vi_hvt_w5_l0p5_m0p40_f1 find vi(n_hvt_w5_l0p5_m0p40) at=178273
.meas ac vi_hvt_w5_l0p5_m0p30_f0 find vi(n_hvt_w5_l0p5_m0p30) at=1000
.meas ac vi_hvt_w5_l0p5_m0p30_f1 find vi(n_hvt_w5_l0p5_m0p30) at=178273
.meas ac vi_hvt_w5_l0p5_m0p20_f0 find vi(n_hvt_w5_l0p5_m0p20) at=1000
.meas ac vi_hvt_w5_l0p5_m0p20_f1 find vi(n_hvt_w5_l0p5_m0p20) at=178273
.meas ac vi_hvt_w5_l0p5_m0p10_f0 find vi(n_hvt_w5_l0p5_m0p10) at=1000
.meas ac vi_hvt_w5_l0p5_m0p10_f1 find vi(n_hvt_w5_l0p5_m0p10) at=178273
.meas ac vi_hvt_w5_l0p5_p0p00_f0 find vi(n_hvt_w5_l0p5_p0p00) at=1000
.meas ac vi_hvt_w5_l0p5_p0p00_f1 find vi(n_hvt_w5_l0p5_p0p00) at=178273
.meas ac vi_hvt_w5_l0p5_p0p10_f0 find vi(n_hvt_w5_l0p5_p0p10) at=1000
.meas ac vi_hvt_w5_l0p5_p0p10_f1 find vi(n_hvt_w5_l0p5_p0p10) at=178273
.meas ac vi_hvt_w5_l0p5_p0p20_f0 find vi(n_hvt_w5_l0p5_p0p20) at=1000
.meas ac vi_hvt_w5_l0p5_p0p20_f1 find vi(n_hvt_w5_l0p5_p0p20) at=178273
.meas ac vi_hvt_w5_l0p5_p0p30_f0 find vi(n_hvt_w5_l0p5_p0p30) at=1000
.meas ac vi_hvt_w5_l0p5_p0p30_f1 find vi(n_hvt_w5_l0p5_p0p30) at=178273
.meas ac vi_hvt_w5_l0p5_p0p40_f0 find vi(n_hvt_w5_l0p5_p0p40) at=1000
.meas ac vi_hvt_w5_l0p5_p0p40_f1 find vi(n_hvt_w5_l0p5_p0p40) at=178273
.meas ac vi_hvt_w5_l0p5_p0p50_f0 find vi(n_hvt_w5_l0p5_p0p50) at=1000
.meas ac vi_hvt_w5_l0p5_p0p50_f1 find vi(n_hvt_w5_l0p5_p0p50) at=178273
.meas ac vi_hvt_w5_l0p5_p0p60_f0 find vi(n_hvt_w5_l0p5_p0p60) at=1000
.meas ac vi_hvt_w5_l0p5_p0p60_f1 find vi(n_hvt_w5_l0p5_p0p60) at=178273
.meas ac vi_hvt_w5_l0p5_p0p70_f0 find vi(n_hvt_w5_l0p5_p0p70) at=1000
.meas ac vi_hvt_w5_l0p5_p0p70_f1 find vi(n_hvt_w5_l0p5_p0p70) at=178273
.meas ac vi_hvt_w5_l0p5_p0p80_f0 find vi(n_hvt_w5_l0p5_p0p80) at=1000
.meas ac vi_hvt_w5_l0p5_p0p80_f1 find vi(n_hvt_w5_l0p5_p0p80) at=178273
.meas ac vi_hvt_w5_l0p5_p0p90_f0 find vi(n_hvt_w5_l0p5_p0p90) at=1000
.meas ac vi_hvt_w5_l0p5_p0p90_f1 find vi(n_hvt_w5_l0p5_p0p90) at=178273
.meas ac vi_hvt_w5_l0p5_p1p00_f0 find vi(n_hvt_w5_l0p5_p1p00) at=1000
.meas ac vi_hvt_w5_l0p5_p1p00_f1 find vi(n_hvt_w5_l0p5_p1p00) at=178273
.meas ac vi_hvt_w5_l0p5_p1p10_f0 find vi(n_hvt_w5_l0p5_p1p10) at=1000
.meas ac vi_hvt_w5_l0p5_p1p10_f1 find vi(n_hvt_w5_l0p5_p1p10) at=178273
.meas ac vi_hvt_w5_l0p5_p1p20_f0 find vi(n_hvt_w5_l0p5_p1p20) at=1000
.meas ac vi_hvt_w5_l0p5_p1p20_f1 find vi(n_hvt_w5_l0p5_p1p20) at=178273
.meas ac vi_hvt_w5_l0p5_p1p30_f0 find vi(n_hvt_w5_l0p5_p1p30) at=1000
.meas ac vi_hvt_w5_l0p5_p1p30_f1 find vi(n_hvt_w5_l0p5_p1p30) at=178273
.meas ac vi_hvt_w5_l0p5_p1p40_f0 find vi(n_hvt_w5_l0p5_p1p40) at=1000
.meas ac vi_hvt_w5_l0p5_p1p40_f1 find vi(n_hvt_w5_l0p5_p1p40) at=178273
.meas ac vi_hvt_w5_l0p5_p1p50_f0 find vi(n_hvt_w5_l0p5_p1p50) at=1000
.meas ac vi_hvt_w5_l0p5_p1p50_f1 find vi(n_hvt_w5_l0p5_p1p50) at=178273
.meas ac vi_hvt_w5_l0p5_p1p60_f0 find vi(n_hvt_w5_l0p5_p1p60) at=1000
.meas ac vi_hvt_w5_l0p5_p1p60_f1 find vi(n_hvt_w5_l0p5_p1p60) at=178273
.meas ac vi_hvt_w5_l0p5_p1p70_f0 find vi(n_hvt_w5_l0p5_p1p70) at=1000
.meas ac vi_hvt_w5_l0p5_p1p70_f1 find vi(n_hvt_w5_l0p5_p1p70) at=178273
.meas ac vi_hvt_w5_l0p5_p1p80_f0 find vi(n_hvt_w5_l0p5_p1p80) at=1000
.meas ac vi_hvt_w5_l0p5_p1p80_f1 find vi(n_hvt_w5_l0p5_p1p80) at=178273
.meas ac vi_hvt_w5_l0p5_p1p90_f0 find vi(n_hvt_w5_l0p5_p1p90) at=1000
.meas ac vi_hvt_w5_l0p5_p1p90_f1 find vi(n_hvt_w5_l0p5_p1p90) at=178273
.meas ac vi_hvt_w5_l0p5_p2p00_f0 find vi(n_hvt_w5_l0p5_p2p00) at=1000
.meas ac vi_hvt_w5_l0p5_p2p00_f1 find vi(n_hvt_w5_l0p5_p2p00) at=178273
.meas ac vi_hvt_w5_l0p5_p2p10_f0 find vi(n_hvt_w5_l0p5_p2p10) at=1000
.meas ac vi_hvt_w5_l0p5_p2p10_f1 find vi(n_hvt_w5_l0p5_p2p10) at=178273
.meas ac vi_hvt_w5_l0p5_p2p20_f0 find vi(n_hvt_w5_l0p5_p2p20) at=1000
.meas ac vi_hvt_w5_l0p5_p2p20_f1 find vi(n_hvt_w5_l0p5_p2p20) at=178273
.meas ac vi_hvt_w5_l0p5_p2p30_f0 find vi(n_hvt_w5_l0p5_p2p30) at=1000
.meas ac vi_hvt_w5_l0p5_p2p30_f1 find vi(n_hvt_w5_l0p5_p2p30) at=178273
.meas ac vi_hvt_w10_l10_m2p30_f0 find vi(n_hvt_w10_l10_m2p30) at=1000
.meas ac vi_hvt_w10_l10_m2p30_f1 find vi(n_hvt_w10_l10_m2p30) at=178273
.meas ac vi_hvt_w10_l10_m2p20_f0 find vi(n_hvt_w10_l10_m2p20) at=1000
.meas ac vi_hvt_w10_l10_m2p20_f1 find vi(n_hvt_w10_l10_m2p20) at=178273
.meas ac vi_hvt_w10_l10_m2p10_f0 find vi(n_hvt_w10_l10_m2p10) at=1000
.meas ac vi_hvt_w10_l10_m2p10_f1 find vi(n_hvt_w10_l10_m2p10) at=178273
.meas ac vi_hvt_w10_l10_m2p00_f0 find vi(n_hvt_w10_l10_m2p00) at=1000
.meas ac vi_hvt_w10_l10_m2p00_f1 find vi(n_hvt_w10_l10_m2p00) at=178273
.meas ac vi_hvt_w10_l10_m1p90_f0 find vi(n_hvt_w10_l10_m1p90) at=1000
.meas ac vi_hvt_w10_l10_m1p90_f1 find vi(n_hvt_w10_l10_m1p90) at=178273
.meas ac vi_hvt_w10_l10_m1p80_f0 find vi(n_hvt_w10_l10_m1p80) at=1000
.meas ac vi_hvt_w10_l10_m1p80_f1 find vi(n_hvt_w10_l10_m1p80) at=178273
.meas ac vi_hvt_w10_l10_m1p70_f0 find vi(n_hvt_w10_l10_m1p70) at=1000
.meas ac vi_hvt_w10_l10_m1p70_f1 find vi(n_hvt_w10_l10_m1p70) at=178273
.meas ac vi_hvt_w10_l10_m1p60_f0 find vi(n_hvt_w10_l10_m1p60) at=1000
.meas ac vi_hvt_w10_l10_m1p60_f1 find vi(n_hvt_w10_l10_m1p60) at=178273
.meas ac vi_hvt_w10_l10_m1p50_f0 find vi(n_hvt_w10_l10_m1p50) at=1000
.meas ac vi_hvt_w10_l10_m1p50_f1 find vi(n_hvt_w10_l10_m1p50) at=178273
.meas ac vi_hvt_w10_l10_m1p40_f0 find vi(n_hvt_w10_l10_m1p40) at=1000
.meas ac vi_hvt_w10_l10_m1p40_f1 find vi(n_hvt_w10_l10_m1p40) at=178273
.meas ac vi_hvt_w10_l10_m1p30_f0 find vi(n_hvt_w10_l10_m1p30) at=1000
.meas ac vi_hvt_w10_l10_m1p30_f1 find vi(n_hvt_w10_l10_m1p30) at=178273
.meas ac vi_hvt_w10_l10_m1p20_f0 find vi(n_hvt_w10_l10_m1p20) at=1000
.meas ac vi_hvt_w10_l10_m1p20_f1 find vi(n_hvt_w10_l10_m1p20) at=178273
.meas ac vi_hvt_w10_l10_m1p10_f0 find vi(n_hvt_w10_l10_m1p10) at=1000
.meas ac vi_hvt_w10_l10_m1p10_f1 find vi(n_hvt_w10_l10_m1p10) at=178273
.meas ac vi_hvt_w10_l10_m1p00_f0 find vi(n_hvt_w10_l10_m1p00) at=1000
.meas ac vi_hvt_w10_l10_m1p00_f1 find vi(n_hvt_w10_l10_m1p00) at=178273
.meas ac vi_hvt_w10_l10_m0p90_f0 find vi(n_hvt_w10_l10_m0p90) at=1000
.meas ac vi_hvt_w10_l10_m0p90_f1 find vi(n_hvt_w10_l10_m0p90) at=178273
.meas ac vi_hvt_w10_l10_m0p80_f0 find vi(n_hvt_w10_l10_m0p80) at=1000
.meas ac vi_hvt_w10_l10_m0p80_f1 find vi(n_hvt_w10_l10_m0p80) at=178273
.meas ac vi_hvt_w10_l10_m0p70_f0 find vi(n_hvt_w10_l10_m0p70) at=1000
.meas ac vi_hvt_w10_l10_m0p70_f1 find vi(n_hvt_w10_l10_m0p70) at=178273
.meas ac vi_hvt_w10_l10_m0p60_f0 find vi(n_hvt_w10_l10_m0p60) at=1000
.meas ac vi_hvt_w10_l10_m0p60_f1 find vi(n_hvt_w10_l10_m0p60) at=178273
.meas ac vi_hvt_w10_l10_m0p50_f0 find vi(n_hvt_w10_l10_m0p50) at=1000
.meas ac vi_hvt_w10_l10_m0p50_f1 find vi(n_hvt_w10_l10_m0p50) at=178273
.meas ac vi_hvt_w10_l10_m0p40_f0 find vi(n_hvt_w10_l10_m0p40) at=1000
.meas ac vi_hvt_w10_l10_m0p40_f1 find vi(n_hvt_w10_l10_m0p40) at=178273
.meas ac vi_hvt_w10_l10_m0p30_f0 find vi(n_hvt_w10_l10_m0p30) at=1000
.meas ac vi_hvt_w10_l10_m0p30_f1 find vi(n_hvt_w10_l10_m0p30) at=178273
.meas ac vi_hvt_w10_l10_m0p20_f0 find vi(n_hvt_w10_l10_m0p20) at=1000
.meas ac vi_hvt_w10_l10_m0p20_f1 find vi(n_hvt_w10_l10_m0p20) at=178273
.meas ac vi_hvt_w10_l10_m0p10_f0 find vi(n_hvt_w10_l10_m0p10) at=1000
.meas ac vi_hvt_w10_l10_m0p10_f1 find vi(n_hvt_w10_l10_m0p10) at=178273
.meas ac vi_hvt_w10_l10_p0p00_f0 find vi(n_hvt_w10_l10_p0p00) at=1000
.meas ac vi_hvt_w10_l10_p0p00_f1 find vi(n_hvt_w10_l10_p0p00) at=178273
.meas ac vi_hvt_w10_l10_p0p10_f0 find vi(n_hvt_w10_l10_p0p10) at=1000
.meas ac vi_hvt_w10_l10_p0p10_f1 find vi(n_hvt_w10_l10_p0p10) at=178273
.meas ac vi_hvt_w10_l10_p0p20_f0 find vi(n_hvt_w10_l10_p0p20) at=1000
.meas ac vi_hvt_w10_l10_p0p20_f1 find vi(n_hvt_w10_l10_p0p20) at=178273
.meas ac vi_hvt_w10_l10_p0p30_f0 find vi(n_hvt_w10_l10_p0p30) at=1000
.meas ac vi_hvt_w10_l10_p0p30_f1 find vi(n_hvt_w10_l10_p0p30) at=178273
.meas ac vi_hvt_w10_l10_p0p40_f0 find vi(n_hvt_w10_l10_p0p40) at=1000
.meas ac vi_hvt_w10_l10_p0p40_f1 find vi(n_hvt_w10_l10_p0p40) at=178273
.meas ac vi_hvt_w10_l10_p0p50_f0 find vi(n_hvt_w10_l10_p0p50) at=1000
.meas ac vi_hvt_w10_l10_p0p50_f1 find vi(n_hvt_w10_l10_p0p50) at=178273
.meas ac vi_hvt_w10_l10_p0p60_f0 find vi(n_hvt_w10_l10_p0p60) at=1000
.meas ac vi_hvt_w10_l10_p0p60_f1 find vi(n_hvt_w10_l10_p0p60) at=178273
.meas ac vi_hvt_w10_l10_p0p70_f0 find vi(n_hvt_w10_l10_p0p70) at=1000
.meas ac vi_hvt_w10_l10_p0p70_f1 find vi(n_hvt_w10_l10_p0p70) at=178273
.meas ac vi_hvt_w10_l10_p0p80_f0 find vi(n_hvt_w10_l10_p0p80) at=1000
.meas ac vi_hvt_w10_l10_p0p80_f1 find vi(n_hvt_w10_l10_p0p80) at=178273
.meas ac vi_hvt_w10_l10_p0p90_f0 find vi(n_hvt_w10_l10_p0p90) at=1000
.meas ac vi_hvt_w10_l10_p0p90_f1 find vi(n_hvt_w10_l10_p0p90) at=178273
.meas ac vi_hvt_w10_l10_p1p00_f0 find vi(n_hvt_w10_l10_p1p00) at=1000
.meas ac vi_hvt_w10_l10_p1p00_f1 find vi(n_hvt_w10_l10_p1p00) at=178273
.meas ac vi_hvt_w10_l10_p1p10_f0 find vi(n_hvt_w10_l10_p1p10) at=1000
.meas ac vi_hvt_w10_l10_p1p10_f1 find vi(n_hvt_w10_l10_p1p10) at=178273
.meas ac vi_hvt_w10_l10_p1p20_f0 find vi(n_hvt_w10_l10_p1p20) at=1000
.meas ac vi_hvt_w10_l10_p1p20_f1 find vi(n_hvt_w10_l10_p1p20) at=178273
.meas ac vi_hvt_w10_l10_p1p30_f0 find vi(n_hvt_w10_l10_p1p30) at=1000
.meas ac vi_hvt_w10_l10_p1p30_f1 find vi(n_hvt_w10_l10_p1p30) at=178273
.meas ac vi_hvt_w10_l10_p1p40_f0 find vi(n_hvt_w10_l10_p1p40) at=1000
.meas ac vi_hvt_w10_l10_p1p40_f1 find vi(n_hvt_w10_l10_p1p40) at=178273
.meas ac vi_hvt_w10_l10_p1p50_f0 find vi(n_hvt_w10_l10_p1p50) at=1000
.meas ac vi_hvt_w10_l10_p1p50_f1 find vi(n_hvt_w10_l10_p1p50) at=178273
.meas ac vi_hvt_w10_l10_p1p60_f0 find vi(n_hvt_w10_l10_p1p60) at=1000
.meas ac vi_hvt_w10_l10_p1p60_f1 find vi(n_hvt_w10_l10_p1p60) at=178273
.meas ac vi_hvt_w10_l10_p1p70_f0 find vi(n_hvt_w10_l10_p1p70) at=1000
.meas ac vi_hvt_w10_l10_p1p70_f1 find vi(n_hvt_w10_l10_p1p70) at=178273
.meas ac vi_hvt_w10_l10_p1p80_f0 find vi(n_hvt_w10_l10_p1p80) at=1000
.meas ac vi_hvt_w10_l10_p1p80_f1 find vi(n_hvt_w10_l10_p1p80) at=178273
.meas ac vi_hvt_w10_l10_p1p90_f0 find vi(n_hvt_w10_l10_p1p90) at=1000
.meas ac vi_hvt_w10_l10_p1p90_f1 find vi(n_hvt_w10_l10_p1p90) at=178273
.meas ac vi_hvt_w10_l10_p2p00_f0 find vi(n_hvt_w10_l10_p2p00) at=1000
.meas ac vi_hvt_w10_l10_p2p00_f1 find vi(n_hvt_w10_l10_p2p00) at=178273
.meas ac vi_hvt_w10_l10_p2p10_f0 find vi(n_hvt_w10_l10_p2p10) at=1000
.meas ac vi_hvt_w10_l10_p2p10_f1 find vi(n_hvt_w10_l10_p2p10) at=178273
.meas ac vi_hvt_w10_l10_p2p20_f0 find vi(n_hvt_w10_l10_p2p20) at=1000
.meas ac vi_hvt_w10_l10_p2p20_f1 find vi(n_hvt_w10_l10_p2p20) at=178273
.meas ac vi_hvt_w10_l10_p2p30_f0 find vi(n_hvt_w10_l10_p2p30) at=1000
.meas ac vi_hvt_w10_l10_p2p30_f1 find vi(n_hvt_w10_l10_p2p30) at=178273
.control
save all
ac lin 3 1000 178273
quit
.endc
.end
