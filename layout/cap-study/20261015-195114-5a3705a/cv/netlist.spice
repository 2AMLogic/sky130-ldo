* varactor C(V) sweep (issue #319): c0 = plate under test, c1 = 0, b = 0
VB_lvt_w5_l0p5_m2p30 b_lvt_w5_l0p5_m2p30 0 dc -2.3
RB_lvt_w5_l0p5_m2p30 b_lvt_w5_l0p5_m2p30 n_lvt_w5_l0p5_m2p30 1e12
IA_lvt_w5_l0p5_m2p30 0 n_lvt_w5_l0p5_m2p30 dc 0 ac 1
X_lvt_w5_l0p5_m2p30 n_lvt_w5_l0p5_m2p30 0 0 sky130_fd_pr__cap_var_lvt w=5 l=0.5
VB_lvt_w5_l0p5_m2p20 b_lvt_w5_l0p5_m2p20 0 dc -2.2
RB_lvt_w5_l0p5_m2p20 b_lvt_w5_l0p5_m2p20 n_lvt_w5_l0p5_m2p20 1e12
IA_lvt_w5_l0p5_m2p20 0 n_lvt_w5_l0p5_m2p20 dc 0 ac 1
X_lvt_w5_l0p5_m2p20 n_lvt_w5_l0p5_m2p20 0 0 sky130_fd_pr__cap_var_lvt w=5 l=0.5
VB_lvt_w5_l0p5_m2p10 b_lvt_w5_l0p5_m2p10 0 dc -2.1
RB_lvt_w5_l0p5_m2p10 b_lvt_w5_l0p5_m2p10 n_lvt_w5_l0p5_m2p10 1e12
IA_lvt_w5_l0p5_m2p10 0 n_lvt_w5_l0p5_m2p10 dc 0 ac 1
X_lvt_w5_l0p5_m2p10 n_lvt_w5_l0p5_m2p10 0 0 sky130_fd_pr__cap_var_lvt w=5 l=0.5
VB_lvt_w5_l0p5_m2p00 b_lvt_w5_l0p5_m2p00 0 dc -2.0
RB_lvt_w5_l0p5_m2p00 b_lvt_w5_l0p5_m2p00 n_lvt_w5_l0p5_m2p00 1e12
IA_lvt_w5_l0p5_m2p00 0 n_lvt_w5_l0p5_m2p00 dc 0 ac 1
X_lvt_w5_l0p5_m2p00 n_lvt_w5_l0p5_m2p00 0 0 sky130_fd_pr__cap_var_lvt w=5 l=0.5
VB_lvt_w5_l0p5_m1p90 b_lvt_w5_l0p5_m1p90 0 dc -1.9
RB_lvt_w5_l0p5_m1p90 b_lvt_w5_l0p5_m1p90 n_lvt_w5_l0p5_m1p90 1e12
IA_lvt_w5_l0p5_m1p90 0 n_lvt_w5_l0p5_m1p90 dc 0 ac 1
X_lvt_w5_l0p5_m1p90 n_lvt_w5_l0p5_m1p90 0 0 sky130_fd_pr__cap_var_lvt w=5 l=0.5
VB_lvt_w5_l0p5_m1p80 b_lvt_w5_l0p5_m1p80 0 dc -1.8
RB_lvt_w5_l0p5_m1p80 b_lvt_w5_l0p5_m1p80 n_lvt_w5_l0p5_m1p80 1e12
IA_lvt_w5_l0p5_m1p80 0 n_lvt_w5_l0p5_m1p80 dc 0 ac 1
X_lvt_w5_l0p5_m1p80 n_lvt_w5_l0p5_m1p80 0 0 sky130_fd_pr__cap_var_lvt w=5 l=0.5
VB_lvt_w5_l0p5_m1p70 b_lvt_w5_l0p5_m1p70 0 dc -1.7
RB_lvt_w5_l0p5_m1p70 b_lvt_w5_l0p5_m1p70 n_lvt_w5_l0p5_m1p70 1e12
IA_lvt_w5_l0p5_m1p70 0 n_lvt_w5_l0p5_m1p70 dc 0 ac 1
X_lvt_w5_l0p5_m1p70 n_lvt_w5_l0p5_m1p70 0 0 sky130_fd_pr__cap_var_lvt w=5 l=0.5
VB_lvt_w5_l0p5_m1p60 b_lvt_w5_l0p5_m1p60 0 dc -1.6
RB_lvt_w5_l0p5_m1p60 b_lvt_w5_l0p5_m1p60 n_lvt_w5_l0p5_m1p60 1e12
IA_lvt_w5_l0p5_m1p60 0 n_lvt_w5_l0p5_m1p60 dc 0 ac 1
X_lvt_w5_l0p5_m1p60 n_lvt_w5_l0p5_m1p60 0 0 sky130_fd_pr__cap_var_lvt w=5 l=0.5
VB_lvt_w5_l0p5_m1p50 b_lvt_w5_l0p5_m1p50 0 dc -1.5
RB_lvt_w5_l0p5_m1p50 b_lvt_w5_l0p5_m1p50 n_lvt_w5_l0p5_m1p50 1e12
IA_lvt_w5_l0p5_m1p50 0 n_lvt_w5_l0p5_m1p50 dc 0 ac 1
X_lvt_w5_l0p5_m1p50 n_lvt_w5_l0p5_m1p50 0 0 sky130_fd_pr__cap_var_lvt w=5 l=0.5
VB_lvt_w5_l0p5_m1p40 b_lvt_w5_l0p5_m1p40 0 dc -1.4
RB_lvt_w5_l0p5_m1p40 b_lvt_w5_l0p5_m1p40 n_lvt_w5_l0p5_m1p40 1e12
IA_lvt_w5_l0p5_m1p40 0 n_lvt_w5_l0p5_m1p40 dc 0 ac 1
X_lvt_w5_l0p5_m1p40 n_lvt_w5_l0p5_m1p40 0 0 sky130_fd_pr__cap_var_lvt w=5 l=0.5
VB_lvt_w5_l0p5_m1p30 b_lvt_w5_l0p5_m1p30 0 dc -1.3
RB_lvt_w5_l0p5_m1p30 b_lvt_w5_l0p5_m1p30 n_lvt_w5_l0p5_m1p30 1e12
IA_lvt_w5_l0p5_m1p30 0 n_lvt_w5_l0p5_m1p30 dc 0 ac 1
X_lvt_w5_l0p5_m1p30 n_lvt_w5_l0p5_m1p30 0 0 sky130_fd_pr__cap_var_lvt w=5 l=0.5
VB_lvt_w5_l0p5_m1p20 b_lvt_w5_l0p5_m1p20 0 dc -1.2
RB_lvt_w5_l0p5_m1p20 b_lvt_w5_l0p5_m1p20 n_lvt_w5_l0p5_m1p20 1e12
IA_lvt_w5_l0p5_m1p20 0 n_lvt_w5_l0p5_m1p20 dc 0 ac 1
X_lvt_w5_l0p5_m1p20 n_lvt_w5_l0p5_m1p20 0 0 sky130_fd_pr__cap_var_lvt w=5 l=0.5
VB_lvt_w5_l0p5_m1p10 b_lvt_w5_l0p5_m1p10 0 dc -1.1
RB_lvt_w5_l0p5_m1p10 b_lvt_w5_l0p5_m1p10 n_lvt_w5_l0p5_m1p10 1e12
IA_lvt_w5_l0p5_m1p10 0 n_lvt_w5_l0p5_m1p10 dc 0 ac 1
X_lvt_w5_l0p5_m1p10 n_lvt_w5_l0p5_m1p10 0 0 sky130_fd_pr__cap_var_lvt w=5 l=0.5
VB_lvt_w5_l0p5_m1p00 b_lvt_w5_l0p5_m1p00 0 dc -1.0
RB_lvt_w5_l0p5_m1p00 b_lvt_w5_l0p5_m1p00 n_lvt_w5_l0p5_m1p00 1e12
IA_lvt_w5_l0p5_m1p00 0 n_lvt_w5_l0p5_m1p00 dc 0 ac 1
X_lvt_w5_l0p5_m1p00 n_lvt_w5_l0p5_m1p00 0 0 sky130_fd_pr__cap_var_lvt w=5 l=0.5
VB_lvt_w5_l0p5_m0p90 b_lvt_w5_l0p5_m0p90 0 dc -0.9
RB_lvt_w5_l0p5_m0p90 b_lvt_w5_l0p5_m0p90 n_lvt_w5_l0p5_m0p90 1e12
IA_lvt_w5_l0p5_m0p90 0 n_lvt_w5_l0p5_m0p90 dc 0 ac 1
X_lvt_w5_l0p5_m0p90 n_lvt_w5_l0p5_m0p90 0 0 sky130_fd_pr__cap_var_lvt w=5 l=0.5
VB_lvt_w5_l0p5_m0p80 b_lvt_w5_l0p5_m0p80 0 dc -0.8
RB_lvt_w5_l0p5_m0p80 b_lvt_w5_l0p5_m0p80 n_lvt_w5_l0p5_m0p80 1e12
IA_lvt_w5_l0p5_m0p80 0 n_lvt_w5_l0p5_m0p80 dc 0 ac 1
X_lvt_w5_l0p5_m0p80 n_lvt_w5_l0p5_m0p80 0 0 sky130_fd_pr__cap_var_lvt w=5 l=0.5
VB_lvt_w5_l0p5_m0p70 b_lvt_w5_l0p5_m0p70 0 dc -0.7
RB_lvt_w5_l0p5_m0p70 b_lvt_w5_l0p5_m0p70 n_lvt_w5_l0p5_m0p70 1e12
IA_lvt_w5_l0p5_m0p70 0 n_lvt_w5_l0p5_m0p70 dc 0 ac 1
X_lvt_w5_l0p5_m0p70 n_lvt_w5_l0p5_m0p70 0 0 sky130_fd_pr__cap_var_lvt w=5 l=0.5
VB_lvt_w5_l0p5_m0p60 b_lvt_w5_l0p5_m0p60 0 dc -0.6
RB_lvt_w5_l0p5_m0p60 b_lvt_w5_l0p5_m0p60 n_lvt_w5_l0p5_m0p60 1e12
IA_lvt_w5_l0p5_m0p60 0 n_lvt_w5_l0p5_m0p60 dc 0 ac 1
X_lvt_w5_l0p5_m0p60 n_lvt_w5_l0p5_m0p60 0 0 sky130_fd_pr__cap_var_lvt w=5 l=0.5
VB_lvt_w5_l0p5_m0p50 b_lvt_w5_l0p5_m0p50 0 dc -0.5
RB_lvt_w5_l0p5_m0p50 b_lvt_w5_l0p5_m0p50 n_lvt_w5_l0p5_m0p50 1e12
IA_lvt_w5_l0p5_m0p50 0 n_lvt_w5_l0p5_m0p50 dc 0 ac 1
X_lvt_w5_l0p5_m0p50 n_lvt_w5_l0p5_m0p50 0 0 sky130_fd_pr__cap_var_lvt w=5 l=0.5
VB_lvt_w5_l0p5_m0p40 b_lvt_w5_l0p5_m0p40 0 dc -0.4
RB_lvt_w5_l0p5_m0p40 b_lvt_w5_l0p5_m0p40 n_lvt_w5_l0p5_m0p40 1e12
IA_lvt_w5_l0p5_m0p40 0 n_lvt_w5_l0p5_m0p40 dc 0 ac 1
X_lvt_w5_l0p5_m0p40 n_lvt_w5_l0p5_m0p40 0 0 sky130_fd_pr__cap_var_lvt w=5 l=0.5
VB_lvt_w5_l0p5_m0p30 b_lvt_w5_l0p5_m0p30 0 dc -0.3
RB_lvt_w5_l0p5_m0p30 b_lvt_w5_l0p5_m0p30 n_lvt_w5_l0p5_m0p30 1e12
IA_lvt_w5_l0p5_m0p30 0 n_lvt_w5_l0p5_m0p30 dc 0 ac 1
X_lvt_w5_l0p5_m0p30 n_lvt_w5_l0p5_m0p30 0 0 sky130_fd_pr__cap_var_lvt w=5 l=0.5
VB_lvt_w5_l0p5_m0p20 b_lvt_w5_l0p5_m0p20 0 dc -0.2
RB_lvt_w5_l0p5_m0p20 b_lvt_w5_l0p5_m0p20 n_lvt_w5_l0p5_m0p20 1e12
IA_lvt_w5_l0p5_m0p20 0 n_lvt_w5_l0p5_m0p20 dc 0 ac 1
X_lvt_w5_l0p5_m0p20 n_lvt_w5_l0p5_m0p20 0 0 sky130_fd_pr__cap_var_lvt w=5 l=0.5
VB_lvt_w5_l0p5_m0p10 b_lvt_w5_l0p5_m0p10 0 dc -0.1
RB_lvt_w5_l0p5_m0p10 b_lvt_w5_l0p5_m0p10 n_lvt_w5_l0p5_m0p10 1e12
IA_lvt_w5_l0p5_m0p10 0 n_lvt_w5_l0p5_m0p10 dc 0 ac 1
X_lvt_w5_l0p5_m0p10 n_lvt_w5_l0p5_m0p10 0 0 sky130_fd_pr__cap_var_lvt w=5 l=0.5
VB_lvt_w5_l0p5_p0p00 b_lvt_w5_l0p5_p0p00 0 dc 0.0
RB_lvt_w5_l0p5_p0p00 b_lvt_w5_l0p5_p0p00 n_lvt_w5_l0p5_p0p00 1e12
IA_lvt_w5_l0p5_p0p00 0 n_lvt_w5_l0p5_p0p00 dc 0 ac 1
X_lvt_w5_l0p5_p0p00 n_lvt_w5_l0p5_p0p00 0 0 sky130_fd_pr__cap_var_lvt w=5 l=0.5
VB_lvt_w5_l0p5_p0p10 b_lvt_w5_l0p5_p0p10 0 dc 0.1
RB_lvt_w5_l0p5_p0p10 b_lvt_w5_l0p5_p0p10 n_lvt_w5_l0p5_p0p10 1e12
IA_lvt_w5_l0p5_p0p10 0 n_lvt_w5_l0p5_p0p10 dc 0 ac 1
X_lvt_w5_l0p5_p0p10 n_lvt_w5_l0p5_p0p10 0 0 sky130_fd_pr__cap_var_lvt w=5 l=0.5
VB_lvt_w5_l0p5_p0p20 b_lvt_w5_l0p5_p0p20 0 dc 0.2
RB_lvt_w5_l0p5_p0p20 b_lvt_w5_l0p5_p0p20 n_lvt_w5_l0p5_p0p20 1e12
IA_lvt_w5_l0p5_p0p20 0 n_lvt_w5_l0p5_p0p20 dc 0 ac 1
X_lvt_w5_l0p5_p0p20 n_lvt_w5_l0p5_p0p20 0 0 sky130_fd_pr__cap_var_lvt w=5 l=0.5
VB_lvt_w5_l0p5_p0p30 b_lvt_w5_l0p5_p0p30 0 dc 0.3
RB_lvt_w5_l0p5_p0p30 b_lvt_w5_l0p5_p0p30 n_lvt_w5_l0p5_p0p30 1e12
IA_lvt_w5_l0p5_p0p30 0 n_lvt_w5_l0p5_p0p30 dc 0 ac 1
X_lvt_w5_l0p5_p0p30 n_lvt_w5_l0p5_p0p30 0 0 sky130_fd_pr__cap_var_lvt w=5 l=0.5
VB_lvt_w5_l0p5_p0p40 b_lvt_w5_l0p5_p0p40 0 dc 0.4
RB_lvt_w5_l0p5_p0p40 b_lvt_w5_l0p5_p0p40 n_lvt_w5_l0p5_p0p40 1e12
IA_lvt_w5_l0p5_p0p40 0 n_lvt_w5_l0p5_p0p40 dc 0 ac 1
X_lvt_w5_l0p5_p0p40 n_lvt_w5_l0p5_p0p40 0 0 sky130_fd_pr__cap_var_lvt w=5 l=0.5
VB_lvt_w5_l0p5_p0p50 b_lvt_w5_l0p5_p0p50 0 dc 0.5
RB_lvt_w5_l0p5_p0p50 b_lvt_w5_l0p5_p0p50 n_lvt_w5_l0p5_p0p50 1e12
IA_lvt_w5_l0p5_p0p50 0 n_lvt_w5_l0p5_p0p50 dc 0 ac 1
X_lvt_w5_l0p5_p0p50 n_lvt_w5_l0p5_p0p50 0 0 sky130_fd_pr__cap_var_lvt w=5 l=0.5
VB_lvt_w5_l0p5_p0p60 b_lvt_w5_l0p5_p0p60 0 dc 0.6
RB_lvt_w5_l0p5_p0p60 b_lvt_w5_l0p5_p0p60 n_lvt_w5_l0p5_p0p60 1e12
IA_lvt_w5_l0p5_p0p60 0 n_lvt_w5_l0p5_p0p60 dc 0 ac 1
X_lvt_w5_l0p5_p0p60 n_lvt_w5_l0p5_p0p60 0 0 sky130_fd_pr__cap_var_lvt w=5 l=0.5
VB_lvt_w5_l0p5_p0p70 b_lvt_w5_l0p5_p0p70 0 dc 0.7
RB_lvt_w5_l0p5_p0p70 b_lvt_w5_l0p5_p0p70 n_lvt_w5_l0p5_p0p70 1e12
IA_lvt_w5_l0p5_p0p70 0 n_lvt_w5_l0p5_p0p70 dc 0 ac 1
X_lvt_w5_l0p5_p0p70 n_lvt_w5_l0p5_p0p70 0 0 sky130_fd_pr__cap_var_lvt w=5 l=0.5
VB_lvt_w5_l0p5_p0p80 b_lvt_w5_l0p5_p0p80 0 dc 0.8
RB_lvt_w5_l0p5_p0p80 b_lvt_w5_l0p5_p0p80 n_lvt_w5_l0p5_p0p80 1e12
IA_lvt_w5_l0p5_p0p80 0 n_lvt_w5_l0p5_p0p80 dc 0 ac 1
X_lvt_w5_l0p5_p0p80 n_lvt_w5_l0p5_p0p80 0 0 sky130_fd_pr__cap_var_lvt w=5 l=0.5
VB_lvt_w5_l0p5_p0p90 b_lvt_w5_l0p5_p0p90 0 dc 0.9
RB_lvt_w5_l0p5_p0p90 b_lvt_w5_l0p5_p0p90 n_lvt_w5_l0p5_p0p90 1e12
IA_lvt_w5_l0p5_p0p90 0 n_lvt_w5_l0p5_p0p90 dc 0 ac 1
X_lvt_w5_l0p5_p0p90 n_lvt_w5_l0p5_p0p90 0 0 sky130_fd_pr__cap_var_lvt w=5 l=0.5
VB_lvt_w5_l0p5_p1p00 b_lvt_w5_l0p5_p1p00 0 dc 1.0
RB_lvt_w5_l0p5_p1p00 b_lvt_w5_l0p5_p1p00 n_lvt_w5_l0p5_p1p00 1e12
IA_lvt_w5_l0p5_p1p00 0 n_lvt_w5_l0p5_p1p00 dc 0 ac 1
X_lvt_w5_l0p5_p1p00 n_lvt_w5_l0p5_p1p00 0 0 sky130_fd_pr__cap_var_lvt w=5 l=0.5
VB_lvt_w5_l0p5_p1p10 b_lvt_w5_l0p5_p1p10 0 dc 1.1
RB_lvt_w5_l0p5_p1p10 b_lvt_w5_l0p5_p1p10 n_lvt_w5_l0p5_p1p10 1e12
IA_lvt_w5_l0p5_p1p10 0 n_lvt_w5_l0p5_p1p10 dc 0 ac 1
X_lvt_w5_l0p5_p1p10 n_lvt_w5_l0p5_p1p10 0 0 sky130_fd_pr__cap_var_lvt w=5 l=0.5
VB_lvt_w5_l0p5_p1p20 b_lvt_w5_l0p5_p1p20 0 dc 1.2
RB_lvt_w5_l0p5_p1p20 b_lvt_w5_l0p5_p1p20 n_lvt_w5_l0p5_p1p20 1e12
IA_lvt_w5_l0p5_p1p20 0 n_lvt_w5_l0p5_p1p20 dc 0 ac 1
X_lvt_w5_l0p5_p1p20 n_lvt_w5_l0p5_p1p20 0 0 sky130_fd_pr__cap_var_lvt w=5 l=0.5
VB_lvt_w5_l0p5_p1p30 b_lvt_w5_l0p5_p1p30 0 dc 1.3
RB_lvt_w5_l0p5_p1p30 b_lvt_w5_l0p5_p1p30 n_lvt_w5_l0p5_p1p30 1e12
IA_lvt_w5_l0p5_p1p30 0 n_lvt_w5_l0p5_p1p30 dc 0 ac 1
X_lvt_w5_l0p5_p1p30 n_lvt_w5_l0p5_p1p30 0 0 sky130_fd_pr__cap_var_lvt w=5 l=0.5
VB_lvt_w5_l0p5_p1p40 b_lvt_w5_l0p5_p1p40 0 dc 1.4
RB_lvt_w5_l0p5_p1p40 b_lvt_w5_l0p5_p1p40 n_lvt_w5_l0p5_p1p40 1e12
IA_lvt_w5_l0p5_p1p40 0 n_lvt_w5_l0p5_p1p40 dc 0 ac 1
X_lvt_w5_l0p5_p1p40 n_lvt_w5_l0p5_p1p40 0 0 sky130_fd_pr__cap_var_lvt w=5 l=0.5
VB_lvt_w5_l0p5_p1p50 b_lvt_w5_l0p5_p1p50 0 dc 1.5
RB_lvt_w5_l0p5_p1p50 b_lvt_w5_l0p5_p1p50 n_lvt_w5_l0p5_p1p50 1e12
IA_lvt_w5_l0p5_p1p50 0 n_lvt_w5_l0p5_p1p50 dc 0 ac 1
X_lvt_w5_l0p5_p1p50 n_lvt_w5_l0p5_p1p50 0 0 sky130_fd_pr__cap_var_lvt w=5 l=0.5
VB_lvt_w5_l0p5_p1p60 b_lvt_w5_l0p5_p1p60 0 dc 1.6
RB_lvt_w5_l0p5_p1p60 b_lvt_w5_l0p5_p1p60 n_lvt_w5_l0p5_p1p60 1e12
IA_lvt_w5_l0p5_p1p60 0 n_lvt_w5_l0p5_p1p60 dc 0 ac 1
X_lvt_w5_l0p5_p1p60 n_lvt_w5_l0p5_p1p60 0 0 sky130_fd_pr__cap_var_lvt w=5 l=0.5
VB_lvt_w5_l0p5_p1p70 b_lvt_w5_l0p5_p1p70 0 dc 1.7
RB_lvt_w5_l0p5_p1p70 b_lvt_w5_l0p5_p1p70 n_lvt_w5_l0p5_p1p70 1e12
IA_lvt_w5_l0p5_p1p70 0 n_lvt_w5_l0p5_p1p70 dc 0 ac 1
X_lvt_w5_l0p5_p1p70 n_lvt_w5_l0p5_p1p70 0 0 sky130_fd_pr__cap_var_lvt w=5 l=0.5
VB_lvt_w5_l0p5_p1p80 b_lvt_w5_l0p5_p1p80 0 dc 1.8
RB_lvt_w5_l0p5_p1p80 b_lvt_w5_l0p5_p1p80 n_lvt_w5_l0p5_p1p80 1e12
IA_lvt_w5_l0p5_p1p80 0 n_lvt_w5_l0p5_p1p80 dc 0 ac 1
X_lvt_w5_l0p5_p1p80 n_lvt_w5_l0p5_p1p80 0 0 sky130_fd_pr__cap_var_lvt w=5 l=0.5
VB_lvt_w5_l0p5_p1p90 b_lvt_w5_l0p5_p1p90 0 dc 1.9
RB_lvt_w5_l0p5_p1p90 b_lvt_w5_l0p5_p1p90 n_lvt_w5_l0p5_p1p90 1e12
IA_lvt_w5_l0p5_p1p90 0 n_lvt_w5_l0p5_p1p90 dc 0 ac 1
X_lvt_w5_l0p5_p1p90 n_lvt_w5_l0p5_p1p90 0 0 sky130_fd_pr__cap_var_lvt w=5 l=0.5
VB_lvt_w5_l0p5_p2p00 b_lvt_w5_l0p5_p2p00 0 dc 2.0
RB_lvt_w5_l0p5_p2p00 b_lvt_w5_l0p5_p2p00 n_lvt_w5_l0p5_p2p00 1e12
IA_lvt_w5_l0p5_p2p00 0 n_lvt_w5_l0p5_p2p00 dc 0 ac 1
X_lvt_w5_l0p5_p2p00 n_lvt_w5_l0p5_p2p00 0 0 sky130_fd_pr__cap_var_lvt w=5 l=0.5
VB_lvt_w5_l0p5_p2p10 b_lvt_w5_l0p5_p2p10 0 dc 2.1
RB_lvt_w5_l0p5_p2p10 b_lvt_w5_l0p5_p2p10 n_lvt_w5_l0p5_p2p10 1e12
IA_lvt_w5_l0p5_p2p10 0 n_lvt_w5_l0p5_p2p10 dc 0 ac 1
X_lvt_w5_l0p5_p2p10 n_lvt_w5_l0p5_p2p10 0 0 sky130_fd_pr__cap_var_lvt w=5 l=0.5
VB_lvt_w5_l0p5_p2p20 b_lvt_w5_l0p5_p2p20 0 dc 2.2
RB_lvt_w5_l0p5_p2p20 b_lvt_w5_l0p5_p2p20 n_lvt_w5_l0p5_p2p20 1e12
IA_lvt_w5_l0p5_p2p20 0 n_lvt_w5_l0p5_p2p20 dc 0 ac 1
X_lvt_w5_l0p5_p2p20 n_lvt_w5_l0p5_p2p20 0 0 sky130_fd_pr__cap_var_lvt w=5 l=0.5
VB_lvt_w5_l0p5_p2p30 b_lvt_w5_l0p5_p2p30 0 dc 2.3
RB_lvt_w5_l0p5_p2p30 b_lvt_w5_l0p5_p2p30 n_lvt_w5_l0p5_p2p30 1e12
IA_lvt_w5_l0p5_p2p30 0 n_lvt_w5_l0p5_p2p30 dc 0 ac 1
X_lvt_w5_l0p5_p2p30 n_lvt_w5_l0p5_p2p30 0 0 sky130_fd_pr__cap_var_lvt w=5 l=0.5
VB_lvt_w10_l10_m2p30 b_lvt_w10_l10_m2p30 0 dc -2.3
RB_lvt_w10_l10_m2p30 b_lvt_w10_l10_m2p30 n_lvt_w10_l10_m2p30 1e12
IA_lvt_w10_l10_m2p30 0 n_lvt_w10_l10_m2p30 dc 0 ac 1
X_lvt_w10_l10_m2p30 n_lvt_w10_l10_m2p30 0 0 sky130_fd_pr__cap_var_lvt w=10 l=10
VB_lvt_w10_l10_m2p20 b_lvt_w10_l10_m2p20 0 dc -2.2
RB_lvt_w10_l10_m2p20 b_lvt_w10_l10_m2p20 n_lvt_w10_l10_m2p20 1e12
IA_lvt_w10_l10_m2p20 0 n_lvt_w10_l10_m2p20 dc 0 ac 1
X_lvt_w10_l10_m2p20 n_lvt_w10_l10_m2p20 0 0 sky130_fd_pr__cap_var_lvt w=10 l=10
VB_lvt_w10_l10_m2p10 b_lvt_w10_l10_m2p10 0 dc -2.1
RB_lvt_w10_l10_m2p10 b_lvt_w10_l10_m2p10 n_lvt_w10_l10_m2p10 1e12
IA_lvt_w10_l10_m2p10 0 n_lvt_w10_l10_m2p10 dc 0 ac 1
X_lvt_w10_l10_m2p10 n_lvt_w10_l10_m2p10 0 0 sky130_fd_pr__cap_var_lvt w=10 l=10
VB_lvt_w10_l10_m2p00 b_lvt_w10_l10_m2p00 0 dc -2.0
RB_lvt_w10_l10_m2p00 b_lvt_w10_l10_m2p00 n_lvt_w10_l10_m2p00 1e12
IA_lvt_w10_l10_m2p00 0 n_lvt_w10_l10_m2p00 dc 0 ac 1
X_lvt_w10_l10_m2p00 n_lvt_w10_l10_m2p00 0 0 sky130_fd_pr__cap_var_lvt w=10 l=10
VB_lvt_w10_l10_m1p90 b_lvt_w10_l10_m1p90 0 dc -1.9
RB_lvt_w10_l10_m1p90 b_lvt_w10_l10_m1p90 n_lvt_w10_l10_m1p90 1e12
IA_lvt_w10_l10_m1p90 0 n_lvt_w10_l10_m1p90 dc 0 ac 1
X_lvt_w10_l10_m1p90 n_lvt_w10_l10_m1p90 0 0 sky130_fd_pr__cap_var_lvt w=10 l=10
VB_lvt_w10_l10_m1p80 b_lvt_w10_l10_m1p80 0 dc -1.8
RB_lvt_w10_l10_m1p80 b_lvt_w10_l10_m1p80 n_lvt_w10_l10_m1p80 1e12
IA_lvt_w10_l10_m1p80 0 n_lvt_w10_l10_m1p80 dc 0 ac 1
X_lvt_w10_l10_m1p80 n_lvt_w10_l10_m1p80 0 0 sky130_fd_pr__cap_var_lvt w=10 l=10
VB_lvt_w10_l10_m1p70 b_lvt_w10_l10_m1p70 0 dc -1.7
RB_lvt_w10_l10_m1p70 b_lvt_w10_l10_m1p70 n_lvt_w10_l10_m1p70 1e12
IA_lvt_w10_l10_m1p70 0 n_lvt_w10_l10_m1p70 dc 0 ac 1
X_lvt_w10_l10_m1p70 n_lvt_w10_l10_m1p70 0 0 sky130_fd_pr__cap_var_lvt w=10 l=10
VB_lvt_w10_l10_m1p60 b_lvt_w10_l10_m1p60 0 dc -1.6
RB_lvt_w10_l10_m1p60 b_lvt_w10_l10_m1p60 n_lvt_w10_l10_m1p60 1e12
IA_lvt_w10_l10_m1p60 0 n_lvt_w10_l10_m1p60 dc 0 ac 1
X_lvt_w10_l10_m1p60 n_lvt_w10_l10_m1p60 0 0 sky130_fd_pr__cap_var_lvt w=10 l=10
VB_lvt_w10_l10_m1p50 b_lvt_w10_l10_m1p50 0 dc -1.5
RB_lvt_w10_l10_m1p50 b_lvt_w10_l10_m1p50 n_lvt_w10_l10_m1p50 1e12
IA_lvt_w10_l10_m1p50 0 n_lvt_w10_l10_m1p50 dc 0 ac 1
X_lvt_w10_l10_m1p50 n_lvt_w10_l10_m1p50 0 0 sky130_fd_pr__cap_var_lvt w=10 l=10
VB_lvt_w10_l10_m1p40 b_lvt_w10_l10_m1p40 0 dc -1.4
RB_lvt_w10_l10_m1p40 b_lvt_w10_l10_m1p40 n_lvt_w10_l10_m1p40 1e12
IA_lvt_w10_l10_m1p40 0 n_lvt_w10_l10_m1p40 dc 0 ac 1
X_lvt_w10_l10_m1p40 n_lvt_w10_l10_m1p40 0 0 sky130_fd_pr__cap_var_lvt w=10 l=10
VB_lvt_w10_l10_m1p30 b_lvt_w10_l10_m1p30 0 dc -1.3
RB_lvt_w10_l10_m1p30 b_lvt_w10_l10_m1p30 n_lvt_w10_l10_m1p30 1e12
IA_lvt_w10_l10_m1p30 0 n_lvt_w10_l10_m1p30 dc 0 ac 1
X_lvt_w10_l10_m1p30 n_lvt_w10_l10_m1p30 0 0 sky130_fd_pr__cap_var_lvt w=10 l=10
VB_lvt_w10_l10_m1p20 b_lvt_w10_l10_m1p20 0 dc -1.2
RB_lvt_w10_l10_m1p20 b_lvt_w10_l10_m1p20 n_lvt_w10_l10_m1p20 1e12
IA_lvt_w10_l10_m1p20 0 n_lvt_w10_l10_m1p20 dc 0 ac 1
X_lvt_w10_l10_m1p20 n_lvt_w10_l10_m1p20 0 0 sky130_fd_pr__cap_var_lvt w=10 l=10
VB_lvt_w10_l10_m1p10 b_lvt_w10_l10_m1p10 0 dc -1.1
RB_lvt_w10_l10_m1p10 b_lvt_w10_l10_m1p10 n_lvt_w10_l10_m1p10 1e12
IA_lvt_w10_l10_m1p10 0 n_lvt_w10_l10_m1p10 dc 0 ac 1
X_lvt_w10_l10_m1p10 n_lvt_w10_l10_m1p10 0 0 sky130_fd_pr__cap_var_lvt w=10 l=10
VB_lvt_w10_l10_m1p00 b_lvt_w10_l10_m1p00 0 dc -1.0
RB_lvt_w10_l10_m1p00 b_lvt_w10_l10_m1p00 n_lvt_w10_l10_m1p00 1e12
IA_lvt_w10_l10_m1p00 0 n_lvt_w10_l10_m1p00 dc 0 ac 1
X_lvt_w10_l10_m1p00 n_lvt_w10_l10_m1p00 0 0 sky130_fd_pr__cap_var_lvt w=10 l=10
VB_lvt_w10_l10_m0p90 b_lvt_w10_l10_m0p90 0 dc -0.9
RB_lvt_w10_l10_m0p90 b_lvt_w10_l10_m0p90 n_lvt_w10_l10_m0p90 1e12
IA_lvt_w10_l10_m0p90 0 n_lvt_w10_l10_m0p90 dc 0 ac 1
X_lvt_w10_l10_m0p90 n_lvt_w10_l10_m0p90 0 0 sky130_fd_pr__cap_var_lvt w=10 l=10
VB_lvt_w10_l10_m0p80 b_lvt_w10_l10_m0p80 0 dc -0.8
RB_lvt_w10_l10_m0p80 b_lvt_w10_l10_m0p80 n_lvt_w10_l10_m0p80 1e12
IA_lvt_w10_l10_m0p80 0 n_lvt_w10_l10_m0p80 dc 0 ac 1
X_lvt_w10_l10_m0p80 n_lvt_w10_l10_m0p80 0 0 sky130_fd_pr__cap_var_lvt w=10 l=10
VB_lvt_w10_l10_m0p70 b_lvt_w10_l10_m0p70 0 dc -0.7
RB_lvt_w10_l10_m0p70 b_lvt_w10_l10_m0p70 n_lvt_w10_l10_m0p70 1e12
IA_lvt_w10_l10_m0p70 0 n_lvt_w10_l10_m0p70 dc 0 ac 1
X_lvt_w10_l10_m0p70 n_lvt_w10_l10_m0p70 0 0 sky130_fd_pr__cap_var_lvt w=10 l=10
VB_lvt_w10_l10_m0p60 b_lvt_w10_l10_m0p60 0 dc -0.6
RB_lvt_w10_l10_m0p60 b_lvt_w10_l10_m0p60 n_lvt_w10_l10_m0p60 1e12
IA_lvt_w10_l10_m0p60 0 n_lvt_w10_l10_m0p60 dc 0 ac 1
X_lvt_w10_l10_m0p60 n_lvt_w10_l10_m0p60 0 0 sky130_fd_pr__cap_var_lvt w=10 l=10
VB_lvt_w10_l10_m0p50 b_lvt_w10_l10_m0p50 0 dc -0.5
RB_lvt_w10_l10_m0p50 b_lvt_w10_l10_m0p50 n_lvt_w10_l10_m0p50 1e12
IA_lvt_w10_l10_m0p50 0 n_lvt_w10_l10_m0p50 dc 0 ac 1
X_lvt_w10_l10_m0p50 n_lvt_w10_l10_m0p50 0 0 sky130_fd_pr__cap_var_lvt w=10 l=10
VB_lvt_w10_l10_m0p40 b_lvt_w10_l10_m0p40 0 dc -0.4
RB_lvt_w10_l10_m0p40 b_lvt_w10_l10_m0p40 n_lvt_w10_l10_m0p40 1e12
IA_lvt_w10_l10_m0p40 0 n_lvt_w10_l10_m0p40 dc 0 ac 1
X_lvt_w10_l10_m0p40 n_lvt_w10_l10_m0p40 0 0 sky130_fd_pr__cap_var_lvt w=10 l=10
VB_lvt_w10_l10_m0p30 b_lvt_w10_l10_m0p30 0 dc -0.3
RB_lvt_w10_l10_m0p30 b_lvt_w10_l10_m0p30 n_lvt_w10_l10_m0p30 1e12
IA_lvt_w10_l10_m0p30 0 n_lvt_w10_l10_m0p30 dc 0 ac 1
X_lvt_w10_l10_m0p30 n_lvt_w10_l10_m0p30 0 0 sky130_fd_pr__cap_var_lvt w=10 l=10
VB_lvt_w10_l10_m0p20 b_lvt_w10_l10_m0p20 0 dc -0.2
RB_lvt_w10_l10_m0p20 b_lvt_w10_l10_m0p20 n_lvt_w10_l10_m0p20 1e12
IA_lvt_w10_l10_m0p20 0 n_lvt_w10_l10_m0p20 dc 0 ac 1
X_lvt_w10_l10_m0p20 n_lvt_w10_l10_m0p20 0 0 sky130_fd_pr__cap_var_lvt w=10 l=10
VB_lvt_w10_l10_m0p10 b_lvt_w10_l10_m0p10 0 dc -0.1
RB_lvt_w10_l10_m0p10 b_lvt_w10_l10_m0p10 n_lvt_w10_l10_m0p10 1e12
IA_lvt_w10_l10_m0p10 0 n_lvt_w10_l10_m0p10 dc 0 ac 1
X_lvt_w10_l10_m0p10 n_lvt_w10_l10_m0p10 0 0 sky130_fd_pr__cap_var_lvt w=10 l=10
VB_lvt_w10_l10_p0p00 b_lvt_w10_l10_p0p00 0 dc 0.0
RB_lvt_w10_l10_p0p00 b_lvt_w10_l10_p0p00 n_lvt_w10_l10_p0p00 1e12
IA_lvt_w10_l10_p0p00 0 n_lvt_w10_l10_p0p00 dc 0 ac 1
X_lvt_w10_l10_p0p00 n_lvt_w10_l10_p0p00 0 0 sky130_fd_pr__cap_var_lvt w=10 l=10
VB_lvt_w10_l10_p0p10 b_lvt_w10_l10_p0p10 0 dc 0.1
RB_lvt_w10_l10_p0p10 b_lvt_w10_l10_p0p10 n_lvt_w10_l10_p0p10 1e12
IA_lvt_w10_l10_p0p10 0 n_lvt_w10_l10_p0p10 dc 0 ac 1
X_lvt_w10_l10_p0p10 n_lvt_w10_l10_p0p10 0 0 sky130_fd_pr__cap_var_lvt w=10 l=10
VB_lvt_w10_l10_p0p20 b_lvt_w10_l10_p0p20 0 dc 0.2
RB_lvt_w10_l10_p0p20 b_lvt_w10_l10_p0p20 n_lvt_w10_l10_p0p20 1e12
IA_lvt_w10_l10_p0p20 0 n_lvt_w10_l10_p0p20 dc 0 ac 1
X_lvt_w10_l10_p0p20 n_lvt_w10_l10_p0p20 0 0 sky130_fd_pr__cap_var_lvt w=10 l=10
VB_lvt_w10_l10_p0p30 b_lvt_w10_l10_p0p30 0 dc 0.3
RB_lvt_w10_l10_p0p30 b_lvt_w10_l10_p0p30 n_lvt_w10_l10_p0p30 1e12
IA_lvt_w10_l10_p0p30 0 n_lvt_w10_l10_p0p30 dc 0 ac 1
X_lvt_w10_l10_p0p30 n_lvt_w10_l10_p0p30 0 0 sky130_fd_pr__cap_var_lvt w=10 l=10
VB_lvt_w10_l10_p0p40 b_lvt_w10_l10_p0p40 0 dc 0.4
RB_lvt_w10_l10_p0p40 b_lvt_w10_l10_p0p40 n_lvt_w10_l10_p0p40 1e12
IA_lvt_w10_l10_p0p40 0 n_lvt_w10_l10_p0p40 dc 0 ac 1
X_lvt_w10_l10_p0p40 n_lvt_w10_l10_p0p40 0 0 sky130_fd_pr__cap_var_lvt w=10 l=10
VB_lvt_w10_l10_p0p50 b_lvt_w10_l10_p0p50 0 dc 0.5
RB_lvt_w10_l10_p0p50 b_lvt_w10_l10_p0p50 n_lvt_w10_l10_p0p50 1e12
IA_lvt_w10_l10_p0p50 0 n_lvt_w10_l10_p0p50 dc 0 ac 1
X_lvt_w10_l10_p0p50 n_lvt_w10_l10_p0p50 0 0 sky130_fd_pr__cap_var_lvt w=10 l=10
VB_lvt_w10_l10_p0p60 b_lvt_w10_l10_p0p60 0 dc 0.6
RB_lvt_w10_l10_p0p60 b_lvt_w10_l10_p0p60 n_lvt_w10_l10_p0p60 1e12
IA_lvt_w10_l10_p0p60 0 n_lvt_w10_l10_p0p60 dc 0 ac 1
X_lvt_w10_l10_p0p60 n_lvt_w10_l10_p0p60 0 0 sky130_fd_pr__cap_var_lvt w=10 l=10
VB_lvt_w10_l10_p0p70 b_lvt_w10_l10_p0p70 0 dc 0.7
RB_lvt_w10_l10_p0p70 b_lvt_w10_l10_p0p70 n_lvt_w10_l10_p0p70 1e12
IA_lvt_w10_l10_p0p70 0 n_lvt_w10_l10_p0p70 dc 0 ac 1
X_lvt_w10_l10_p0p70 n_lvt_w10_l10_p0p70 0 0 sky130_fd_pr__cap_var_lvt w=10 l=10
VB_lvt_w10_l10_p0p80 b_lvt_w10_l10_p0p80 0 dc 0.8
RB_lvt_w10_l10_p0p80 b_lvt_w10_l10_p0p80 n_lvt_w10_l10_p0p80 1e12
IA_lvt_w10_l10_p0p80 0 n_lvt_w10_l10_p0p80 dc 0 ac 1
X_lvt_w10_l10_p0p80 n_lvt_w10_l10_p0p80 0 0 sky130_fd_pr__cap_var_lvt w=10 l=10
VB_lvt_w10_l10_p0p90 b_lvt_w10_l10_p0p90 0 dc 0.9
RB_lvt_w10_l10_p0p90 b_lvt_w10_l10_p0p90 n_lvt_w10_l10_p0p90 1e12
IA_lvt_w10_l10_p0p90 0 n_lvt_w10_l10_p0p90 dc 0 ac 1
X_lvt_w10_l10_p0p90 n_lvt_w10_l10_p0p90 0 0 sky130_fd_pr__cap_var_lvt w=10 l=10
VB_lvt_w10_l10_p1p00 b_lvt_w10_l10_p1p00 0 dc 1.0
RB_lvt_w10_l10_p1p00 b_lvt_w10_l10_p1p00 n_lvt_w10_l10_p1p00 1e12
IA_lvt_w10_l10_p1p00 0 n_lvt_w10_l10_p1p00 dc 0 ac 1
X_lvt_w10_l10_p1p00 n_lvt_w10_l10_p1p00 0 0 sky130_fd_pr__cap_var_lvt w=10 l=10
VB_lvt_w10_l10_p1p10 b_lvt_w10_l10_p1p10 0 dc 1.1
RB_lvt_w10_l10_p1p10 b_lvt_w10_l10_p1p10 n_lvt_w10_l10_p1p10 1e12
IA_lvt_w10_l10_p1p10 0 n_lvt_w10_l10_p1p10 dc 0 ac 1
X_lvt_w10_l10_p1p10 n_lvt_w10_l10_p1p10 0 0 sky130_fd_pr__cap_var_lvt w=10 l=10
VB_lvt_w10_l10_p1p20 b_lvt_w10_l10_p1p20 0 dc 1.2
RB_lvt_w10_l10_p1p20 b_lvt_w10_l10_p1p20 n_lvt_w10_l10_p1p20 1e12
IA_lvt_w10_l10_p1p20 0 n_lvt_w10_l10_p1p20 dc 0 ac 1
X_lvt_w10_l10_p1p20 n_lvt_w10_l10_p1p20 0 0 sky130_fd_pr__cap_var_lvt w=10 l=10
VB_lvt_w10_l10_p1p30 b_lvt_w10_l10_p1p30 0 dc 1.3
RB_lvt_w10_l10_p1p30 b_lvt_w10_l10_p1p30 n_lvt_w10_l10_p1p30 1e12
IA_lvt_w10_l10_p1p30 0 n_lvt_w10_l10_p1p30 dc 0 ac 1
X_lvt_w10_l10_p1p30 n_lvt_w10_l10_p1p30 0 0 sky130_fd_pr__cap_var_lvt w=10 l=10
VB_lvt_w10_l10_p1p40 b_lvt_w10_l10_p1p40 0 dc 1.4
RB_lvt_w10_l10_p1p40 b_lvt_w10_l10_p1p40 n_lvt_w10_l10_p1p40 1e12
IA_lvt_w10_l10_p1p40 0 n_lvt_w10_l10_p1p40 dc 0 ac 1
X_lvt_w10_l10_p1p40 n_lvt_w10_l10_p1p40 0 0 sky130_fd_pr__cap_var_lvt w=10 l=10
VB_lvt_w10_l10_p1p50 b_lvt_w10_l10_p1p50 0 dc 1.5
RB_lvt_w10_l10_p1p50 b_lvt_w10_l10_p1p50 n_lvt_w10_l10_p1p50 1e12
IA_lvt_w10_l10_p1p50 0 n_lvt_w10_l10_p1p50 dc 0 ac 1
X_lvt_w10_l10_p1p50 n_lvt_w10_l10_p1p50 0 0 sky130_fd_pr__cap_var_lvt w=10 l=10
VB_lvt_w10_l10_p1p60 b_lvt_w10_l10_p1p60 0 dc 1.6
RB_lvt_w10_l10_p1p60 b_lvt_w10_l10_p1p60 n_lvt_w10_l10_p1p60 1e12
IA_lvt_w10_l10_p1p60 0 n_lvt_w10_l10_p1p60 dc 0 ac 1
X_lvt_w10_l10_p1p60 n_lvt_w10_l10_p1p60 0 0 sky130_fd_pr__cap_var_lvt w=10 l=10
VB_lvt_w10_l10_p1p70 b_lvt_w10_l10_p1p70 0 dc 1.7
RB_lvt_w10_l10_p1p70 b_lvt_w10_l10_p1p70 n_lvt_w10_l10_p1p70 1e12
IA_lvt_w10_l10_p1p70 0 n_lvt_w10_l10_p1p70 dc 0 ac 1
X_lvt_w10_l10_p1p70 n_lvt_w10_l10_p1p70 0 0 sky130_fd_pr__cap_var_lvt w=10 l=10
VB_lvt_w10_l10_p1p80 b_lvt_w10_l10_p1p80 0 dc 1.8
RB_lvt_w10_l10_p1p80 b_lvt_w10_l10_p1p80 n_lvt_w10_l10_p1p80 1e12
IA_lvt_w10_l10_p1p80 0 n_lvt_w10_l10_p1p80 dc 0 ac 1
X_lvt_w10_l10_p1p80 n_lvt_w10_l10_p1p80 0 0 sky130_fd_pr__cap_var_lvt w=10 l=10
VB_lvt_w10_l10_p1p90 b_lvt_w10_l10_p1p90 0 dc 1.9
RB_lvt_w10_l10_p1p90 b_lvt_w10_l10_p1p90 n_lvt_w10_l10_p1p90 1e12
IA_lvt_w10_l10_p1p90 0 n_lvt_w10_l10_p1p90 dc 0 ac 1
X_lvt_w10_l10_p1p90 n_lvt_w10_l10_p1p90 0 0 sky130_fd_pr__cap_var_lvt w=10 l=10
VB_lvt_w10_l10_p2p00 b_lvt_w10_l10_p2p00 0 dc 2.0
RB_lvt_w10_l10_p2p00 b_lvt_w10_l10_p2p00 n_lvt_w10_l10_p2p00 1e12
IA_lvt_w10_l10_p2p00 0 n_lvt_w10_l10_p2p00 dc 0 ac 1
X_lvt_w10_l10_p2p00 n_lvt_w10_l10_p2p00 0 0 sky130_fd_pr__cap_var_lvt w=10 l=10
VB_lvt_w10_l10_p2p10 b_lvt_w10_l10_p2p10 0 dc 2.1
RB_lvt_w10_l10_p2p10 b_lvt_w10_l10_p2p10 n_lvt_w10_l10_p2p10 1e12
IA_lvt_w10_l10_p2p10 0 n_lvt_w10_l10_p2p10 dc 0 ac 1
X_lvt_w10_l10_p2p10 n_lvt_w10_l10_p2p10 0 0 sky130_fd_pr__cap_var_lvt w=10 l=10
VB_lvt_w10_l10_p2p20 b_lvt_w10_l10_p2p20 0 dc 2.2
RB_lvt_w10_l10_p2p20 b_lvt_w10_l10_p2p20 n_lvt_w10_l10_p2p20 1e12
IA_lvt_w10_l10_p2p20 0 n_lvt_w10_l10_p2p20 dc 0 ac 1
X_lvt_w10_l10_p2p20 n_lvt_w10_l10_p2p20 0 0 sky130_fd_pr__cap_var_lvt w=10 l=10
VB_lvt_w10_l10_p2p30 b_lvt_w10_l10_p2p30 0 dc 2.3
RB_lvt_w10_l10_p2p30 b_lvt_w10_l10_p2p30 n_lvt_w10_l10_p2p30 1e12
IA_lvt_w10_l10_p2p30 0 n_lvt_w10_l10_p2p30 dc 0 ac 1
X_lvt_w10_l10_p2p30 n_lvt_w10_l10_p2p30 0 0 sky130_fd_pr__cap_var_lvt w=10 l=10
VB_hvt_w5_l0p5_m2p30 b_hvt_w5_l0p5_m2p30 0 dc -2.3
RB_hvt_w5_l0p5_m2p30 b_hvt_w5_l0p5_m2p30 n_hvt_w5_l0p5_m2p30 1e12
IA_hvt_w5_l0p5_m2p30 0 n_hvt_w5_l0p5_m2p30 dc 0 ac 1
X_hvt_w5_l0p5_m2p30 n_hvt_w5_l0p5_m2p30 0 0 sky130_fd_pr__cap_var_hvt w=5 l=0.5
VB_hvt_w5_l0p5_m2p20 b_hvt_w5_l0p5_m2p20 0 dc -2.2
RB_hvt_w5_l0p5_m2p20 b_hvt_w5_l0p5_m2p20 n_hvt_w5_l0p5_m2p20 1e12
IA_hvt_w5_l0p5_m2p20 0 n_hvt_w5_l0p5_m2p20 dc 0 ac 1
X_hvt_w5_l0p5_m2p20 n_hvt_w5_l0p5_m2p20 0 0 sky130_fd_pr__cap_var_hvt w=5 l=0.5
VB_hvt_w5_l0p5_m2p10 b_hvt_w5_l0p5_m2p10 0 dc -2.1
RB_hvt_w5_l0p5_m2p10 b_hvt_w5_l0p5_m2p10 n_hvt_w5_l0p5_m2p10 1e12
IA_hvt_w5_l0p5_m2p10 0 n_hvt_w5_l0p5_m2p10 dc 0 ac 1
X_hvt_w5_l0p5_m2p10 n_hvt_w5_l0p5_m2p10 0 0 sky130_fd_pr__cap_var_hvt w=5 l=0.5
VB_hvt_w5_l0p5_m2p00 b_hvt_w5_l0p5_m2p00 0 dc -2.0
RB_hvt_w5_l0p5_m2p00 b_hvt_w5_l0p5_m2p00 n_hvt_w5_l0p5_m2p00 1e12
IA_hvt_w5_l0p5_m2p00 0 n_hvt_w5_l0p5_m2p00 dc 0 ac 1
X_hvt_w5_l0p5_m2p00 n_hvt_w5_l0p5_m2p00 0 0 sky130_fd_pr__cap_var_hvt w=5 l=0.5
VB_hvt_w5_l0p5_m1p90 b_hvt_w5_l0p5_m1p90 0 dc -1.9
RB_hvt_w5_l0p5_m1p90 b_hvt_w5_l0p5_m1p90 n_hvt_w5_l0p5_m1p90 1e12
IA_hvt_w5_l0p5_m1p90 0 n_hvt_w5_l0p5_m1p90 dc 0 ac 1
X_hvt_w5_l0p5_m1p90 n_hvt_w5_l0p5_m1p90 0 0 sky130_fd_pr__cap_var_hvt w=5 l=0.5
VB_hvt_w5_l0p5_m1p80 b_hvt_w5_l0p5_m1p80 0 dc -1.8
RB_hvt_w5_l0p5_m1p80 b_hvt_w5_l0p5_m1p80 n_hvt_w5_l0p5_m1p80 1e12
IA_hvt_w5_l0p5_m1p80 0 n_hvt_w5_l0p5_m1p80 dc 0 ac 1
X_hvt_w5_l0p5_m1p80 n_hvt_w5_l0p5_m1p80 0 0 sky130_fd_pr__cap_var_hvt w=5 l=0.5
VB_hvt_w5_l0p5_m1p70 b_hvt_w5_l0p5_m1p70 0 dc -1.7
RB_hvt_w5_l0p5_m1p70 b_hvt_w5_l0p5_m1p70 n_hvt_w5_l0p5_m1p70 1e12
IA_hvt_w5_l0p5_m1p70 0 n_hvt_w5_l0p5_m1p70 dc 0 ac 1
X_hvt_w5_l0p5_m1p70 n_hvt_w5_l0p5_m1p70 0 0 sky130_fd_pr__cap_var_hvt w=5 l=0.5
VB_hvt_w5_l0p5_m1p60 b_hvt_w5_l0p5_m1p60 0 dc -1.6
RB_hvt_w5_l0p5_m1p60 b_hvt_w5_l0p5_m1p60 n_hvt_w5_l0p5_m1p60 1e12
IA_hvt_w5_l0p5_m1p60 0 n_hvt_w5_l0p5_m1p60 dc 0 ac 1
X_hvt_w5_l0p5_m1p60 n_hvt_w5_l0p5_m1p60 0 0 sky130_fd_pr__cap_var_hvt w=5 l=0.5
VB_hvt_w5_l0p5_m1p50 b_hvt_w5_l0p5_m1p50 0 dc -1.5
RB_hvt_w5_l0p5_m1p50 b_hvt_w5_l0p5_m1p50 n_hvt_w5_l0p5_m1p50 1e12
IA_hvt_w5_l0p5_m1p50 0 n_hvt_w5_l0p5_m1p50 dc 0 ac 1
X_hvt_w5_l0p5_m1p50 n_hvt_w5_l0p5_m1p50 0 0 sky130_fd_pr__cap_var_hvt w=5 l=0.5
VB_hvt_w5_l0p5_m1p40 b_hvt_w5_l0p5_m1p40 0 dc -1.4
RB_hvt_w5_l0p5_m1p40 b_hvt_w5_l0p5_m1p40 n_hvt_w5_l0p5_m1p40 1e12
IA_hvt_w5_l0p5_m1p40 0 n_hvt_w5_l0p5_m1p40 dc 0 ac 1
X_hvt_w5_l0p5_m1p40 n_hvt_w5_l0p5_m1p40 0 0 sky130_fd_pr__cap_var_hvt w=5 l=0.5
VB_hvt_w5_l0p5_m1p30 b_hvt_w5_l0p5_m1p30 0 dc -1.3
RB_hvt_w5_l0p5_m1p30 b_hvt_w5_l0p5_m1p30 n_hvt_w5_l0p5_m1p30 1e12
IA_hvt_w5_l0p5_m1p30 0 n_hvt_w5_l0p5_m1p30 dc 0 ac 1
X_hvt_w5_l0p5_m1p30 n_hvt_w5_l0p5_m1p30 0 0 sky130_fd_pr__cap_var_hvt w=5 l=0.5
VB_hvt_w5_l0p5_m1p20 b_hvt_w5_l0p5_m1p20 0 dc -1.2
RB_hvt_w5_l0p5_m1p20 b_hvt_w5_l0p5_m1p20 n_hvt_w5_l0p5_m1p20 1e12
IA_hvt_w5_l0p5_m1p20 0 n_hvt_w5_l0p5_m1p20 dc 0 ac 1
X_hvt_w5_l0p5_m1p20 n_hvt_w5_l0p5_m1p20 0 0 sky130_fd_pr__cap_var_hvt w=5 l=0.5
VB_hvt_w5_l0p5_m1p10 b_hvt_w5_l0p5_m1p10 0 dc -1.1
RB_hvt_w5_l0p5_m1p10 b_hvt_w5_l0p5_m1p10 n_hvt_w5_l0p5_m1p10 1e12
IA_hvt_w5_l0p5_m1p10 0 n_hvt_w5_l0p5_m1p10 dc 0 ac 1
X_hvt_w5_l0p5_m1p10 n_hvt_w5_l0p5_m1p10 0 0 sky130_fd_pr__cap_var_hvt w=5 l=0.5
VB_hvt_w5_l0p5_m1p00 b_hvt_w5_l0p5_m1p00 0 dc -1.0
RB_hvt_w5_l0p5_m1p00 b_hvt_w5_l0p5_m1p00 n_hvt_w5_l0p5_m1p00 1e12
IA_hvt_w5_l0p5_m1p00 0 n_hvt_w5_l0p5_m1p00 dc 0 ac 1
X_hvt_w5_l0p5_m1p00 n_hvt_w5_l0p5_m1p00 0 0 sky130_fd_pr__cap_var_hvt w=5 l=0.5
VB_hvt_w5_l0p5_m0p90 b_hvt_w5_l0p5_m0p90 0 dc -0.9
RB_hvt_w5_l0p5_m0p90 b_hvt_w5_l0p5_m0p90 n_hvt_w5_l0p5_m0p90 1e12
IA_hvt_w5_l0p5_m0p90 0 n_hvt_w5_l0p5_m0p90 dc 0 ac 1
X_hvt_w5_l0p5_m0p90 n_hvt_w5_l0p5_m0p90 0 0 sky130_fd_pr__cap_var_hvt w=5 l=0.5
VB_hvt_w5_l0p5_m0p80 b_hvt_w5_l0p5_m0p80 0 dc -0.8
RB_hvt_w5_l0p5_m0p80 b_hvt_w5_l0p5_m0p80 n_hvt_w5_l0p5_m0p80 1e12
IA_hvt_w5_l0p5_m0p80 0 n_hvt_w5_l0p5_m0p80 dc 0 ac 1
X_hvt_w5_l0p5_m0p80 n_hvt_w5_l0p5_m0p80 0 0 sky130_fd_pr__cap_var_hvt w=5 l=0.5
VB_hvt_w5_l0p5_m0p70 b_hvt_w5_l0p5_m0p70 0 dc -0.7
RB_hvt_w5_l0p5_m0p70 b_hvt_w5_l0p5_m0p70 n_hvt_w5_l0p5_m0p70 1e12
IA_hvt_w5_l0p5_m0p70 0 n_hvt_w5_l0p5_m0p70 dc 0 ac 1
X_hvt_w5_l0p5_m0p70 n_hvt_w5_l0p5_m0p70 0 0 sky130_fd_pr__cap_var_hvt w=5 l=0.5
VB_hvt_w5_l0p5_m0p60 b_hvt_w5_l0p5_m0p60 0 dc -0.6
RB_hvt_w5_l0p5_m0p60 b_hvt_w5_l0p5_m0p60 n_hvt_w5_l0p5_m0p60 1e12
IA_hvt_w5_l0p5_m0p60 0 n_hvt_w5_l0p5_m0p60 dc 0 ac 1
X_hvt_w5_l0p5_m0p60 n_hvt_w5_l0p5_m0p60 0 0 sky130_fd_pr__cap_var_hvt w=5 l=0.5
VB_hvt_w5_l0p5_m0p50 b_hvt_w5_l0p5_m0p50 0 dc -0.5
RB_hvt_w5_l0p5_m0p50 b_hvt_w5_l0p5_m0p50 n_hvt_w5_l0p5_m0p50 1e12
IA_hvt_w5_l0p5_m0p50 0 n_hvt_w5_l0p5_m0p50 dc 0 ac 1
X_hvt_w5_l0p5_m0p50 n_hvt_w5_l0p5_m0p50 0 0 sky130_fd_pr__cap_var_hvt w=5 l=0.5
VB_hvt_w5_l0p5_m0p40 b_hvt_w5_l0p5_m0p40 0 dc -0.4
RB_hvt_w5_l0p5_m0p40 b_hvt_w5_l0p5_m0p40 n_hvt_w5_l0p5_m0p40 1e12
IA_hvt_w5_l0p5_m0p40 0 n_hvt_w5_l0p5_m0p40 dc 0 ac 1
X_hvt_w5_l0p5_m0p40 n_hvt_w5_l0p5_m0p40 0 0 sky130_fd_pr__cap_var_hvt w=5 l=0.5
VB_hvt_w5_l0p5_m0p30 b_hvt_w5_l0p5_m0p30 0 dc -0.3
RB_hvt_w5_l0p5_m0p30 b_hvt_w5_l0p5_m0p30 n_hvt_w5_l0p5_m0p30 1e12
IA_hvt_w5_l0p5_m0p30 0 n_hvt_w5_l0p5_m0p30 dc 0 ac 1
X_hvt_w5_l0p5_m0p30 n_hvt_w5_l0p5_m0p30 0 0 sky130_fd_pr__cap_var_hvt w=5 l=0.5
VB_hvt_w5_l0p5_m0p20 b_hvt_w5_l0p5_m0p20 0 dc -0.2
RB_hvt_w5_l0p5_m0p20 b_hvt_w5_l0p5_m0p20 n_hvt_w5_l0p5_m0p20 1e12
IA_hvt_w5_l0p5_m0p20 0 n_hvt_w5_l0p5_m0p20 dc 0 ac 1
X_hvt_w5_l0p5_m0p20 n_hvt_w5_l0p5_m0p20 0 0 sky130_fd_pr__cap_var_hvt w=5 l=0.5
VB_hvt_w5_l0p5_m0p10 b_hvt_w5_l0p5_m0p10 0 dc -0.1
RB_hvt_w5_l0p5_m0p10 b_hvt_w5_l0p5_m0p10 n_hvt_w5_l0p5_m0p10 1e12
IA_hvt_w5_l0p5_m0p10 0 n_hvt_w5_l0p5_m0p10 dc 0 ac 1
X_hvt_w5_l0p5_m0p10 n_hvt_w5_l0p5_m0p10 0 0 sky130_fd_pr__cap_var_hvt w=5 l=0.5
VB_hvt_w5_l0p5_p0p00 b_hvt_w5_l0p5_p0p00 0 dc 0.0
RB_hvt_w5_l0p5_p0p00 b_hvt_w5_l0p5_p0p00 n_hvt_w5_l0p5_p0p00 1e12
IA_hvt_w5_l0p5_p0p00 0 n_hvt_w5_l0p5_p0p00 dc 0 ac 1
X_hvt_w5_l0p5_p0p00 n_hvt_w5_l0p5_p0p00 0 0 sky130_fd_pr__cap_var_hvt w=5 l=0.5
VB_hvt_w5_l0p5_p0p10 b_hvt_w5_l0p5_p0p10 0 dc 0.1
RB_hvt_w5_l0p5_p0p10 b_hvt_w5_l0p5_p0p10 n_hvt_w5_l0p5_p0p10 1e12
IA_hvt_w5_l0p5_p0p10 0 n_hvt_w5_l0p5_p0p10 dc 0 ac 1
X_hvt_w5_l0p5_p0p10 n_hvt_w5_l0p5_p0p10 0 0 sky130_fd_pr__cap_var_hvt w=5 l=0.5
VB_hvt_w5_l0p5_p0p20 b_hvt_w5_l0p5_p0p20 0 dc 0.2
RB_hvt_w5_l0p5_p0p20 b_hvt_w5_l0p5_p0p20 n_hvt_w5_l0p5_p0p20 1e12
IA_hvt_w5_l0p5_p0p20 0 n_hvt_w5_l0p5_p0p20 dc 0 ac 1
X_hvt_w5_l0p5_p0p20 n_hvt_w5_l0p5_p0p20 0 0 sky130_fd_pr__cap_var_hvt w=5 l=0.5
VB_hvt_w5_l0p5_p0p30 b_hvt_w5_l0p5_p0p30 0 dc 0.3
RB_hvt_w5_l0p5_p0p30 b_hvt_w5_l0p5_p0p30 n_hvt_w5_l0p5_p0p30 1e12
IA_hvt_w5_l0p5_p0p30 0 n_hvt_w5_l0p5_p0p30 dc 0 ac 1
X_hvt_w5_l0p5_p0p30 n_hvt_w5_l0p5_p0p30 0 0 sky130_fd_pr__cap_var_hvt w=5 l=0.5
VB_hvt_w5_l0p5_p0p40 b_hvt_w5_l0p5_p0p40 0 dc 0.4
RB_hvt_w5_l0p5_p0p40 b_hvt_w5_l0p5_p0p40 n_hvt_w5_l0p5_p0p40 1e12
IA_hvt_w5_l0p5_p0p40 0 n_hvt_w5_l0p5_p0p40 dc 0 ac 1
X_hvt_w5_l0p5_p0p40 n_hvt_w5_l0p5_p0p40 0 0 sky130_fd_pr__cap_var_hvt w=5 l=0.5
VB_hvt_w5_l0p5_p0p50 b_hvt_w5_l0p5_p0p50 0 dc 0.5
RB_hvt_w5_l0p5_p0p50 b_hvt_w5_l0p5_p0p50 n_hvt_w5_l0p5_p0p50 1e12
IA_hvt_w5_l0p5_p0p50 0 n_hvt_w5_l0p5_p0p50 dc 0 ac 1
X_hvt_w5_l0p5_p0p50 n_hvt_w5_l0p5_p0p50 0 0 sky130_fd_pr__cap_var_hvt w=5 l=0.5
VB_hvt_w5_l0p5_p0p60 b_hvt_w5_l0p5_p0p60 0 dc 0.6
RB_hvt_w5_l0p5_p0p60 b_hvt_w5_l0p5_p0p60 n_hvt_w5_l0p5_p0p60 1e12
IA_hvt_w5_l0p5_p0p60 0 n_hvt_w5_l0p5_p0p60 dc 0 ac 1
X_hvt_w5_l0p5_p0p60 n_hvt_w5_l0p5_p0p60 0 0 sky130_fd_pr__cap_var_hvt w=5 l=0.5
VB_hvt_w5_l0p5_p0p70 b_hvt_w5_l0p5_p0p70 0 dc 0.7
RB_hvt_w5_l0p5_p0p70 b_hvt_w5_l0p5_p0p70 n_hvt_w5_l0p5_p0p70 1e12
IA_hvt_w5_l0p5_p0p70 0 n_hvt_w5_l0p5_p0p70 dc 0 ac 1
X_hvt_w5_l0p5_p0p70 n_hvt_w5_l0p5_p0p70 0 0 sky130_fd_pr__cap_var_hvt w=5 l=0.5
VB_hvt_w5_l0p5_p0p80 b_hvt_w5_l0p5_p0p80 0 dc 0.8
RB_hvt_w5_l0p5_p0p80 b_hvt_w5_l0p5_p0p80 n_hvt_w5_l0p5_p0p80 1e12
IA_hvt_w5_l0p5_p0p80 0 n_hvt_w5_l0p5_p0p80 dc 0 ac 1
X_hvt_w5_l0p5_p0p80 n_hvt_w5_l0p5_p0p80 0 0 sky130_fd_pr__cap_var_hvt w=5 l=0.5
VB_hvt_w5_l0p5_p0p90 b_hvt_w5_l0p5_p0p90 0 dc 0.9
RB_hvt_w5_l0p5_p0p90 b_hvt_w5_l0p5_p0p90 n_hvt_w5_l0p5_p0p90 1e12
IA_hvt_w5_l0p5_p0p90 0 n_hvt_w5_l0p5_p0p90 dc 0 ac 1
X_hvt_w5_l0p5_p0p90 n_hvt_w5_l0p5_p0p90 0 0 sky130_fd_pr__cap_var_hvt w=5 l=0.5
VB_hvt_w5_l0p5_p1p00 b_hvt_w5_l0p5_p1p00 0 dc 1.0
RB_hvt_w5_l0p5_p1p00 b_hvt_w5_l0p5_p1p00 n_hvt_w5_l0p5_p1p00 1e12
IA_hvt_w5_l0p5_p1p00 0 n_hvt_w5_l0p5_p1p00 dc 0 ac 1
X_hvt_w5_l0p5_p1p00 n_hvt_w5_l0p5_p1p00 0 0 sky130_fd_pr__cap_var_hvt w=5 l=0.5
VB_hvt_w5_l0p5_p1p10 b_hvt_w5_l0p5_p1p10 0 dc 1.1
RB_hvt_w5_l0p5_p1p10 b_hvt_w5_l0p5_p1p10 n_hvt_w5_l0p5_p1p10 1e12
IA_hvt_w5_l0p5_p1p10 0 n_hvt_w5_l0p5_p1p10 dc 0 ac 1
X_hvt_w5_l0p5_p1p10 n_hvt_w5_l0p5_p1p10 0 0 sky130_fd_pr__cap_var_hvt w=5 l=0.5
VB_hvt_w5_l0p5_p1p20 b_hvt_w5_l0p5_p1p20 0 dc 1.2
RB_hvt_w5_l0p5_p1p20 b_hvt_w5_l0p5_p1p20 n_hvt_w5_l0p5_p1p20 1e12
IA_hvt_w5_l0p5_p1p20 0 n_hvt_w5_l0p5_p1p20 dc 0 ac 1
X_hvt_w5_l0p5_p1p20 n_hvt_w5_l0p5_p1p20 0 0 sky130_fd_pr__cap_var_hvt w=5 l=0.5
VB_hvt_w5_l0p5_p1p30 b_hvt_w5_l0p5_p1p30 0 dc 1.3
RB_hvt_w5_l0p5_p1p30 b_hvt_w5_l0p5_p1p30 n_hvt_w5_l0p5_p1p30 1e12
IA_hvt_w5_l0p5_p1p30 0 n_hvt_w5_l0p5_p1p30 dc 0 ac 1
X_hvt_w5_l0p5_p1p30 n_hvt_w5_l0p5_p1p30 0 0 sky130_fd_pr__cap_var_hvt w=5 l=0.5
VB_hvt_w5_l0p5_p1p40 b_hvt_w5_l0p5_p1p40 0 dc 1.4
RB_hvt_w5_l0p5_p1p40 b_hvt_w5_l0p5_p1p40 n_hvt_w5_l0p5_p1p40 1e12
IA_hvt_w5_l0p5_p1p40 0 n_hvt_w5_l0p5_p1p40 dc 0 ac 1
X_hvt_w5_l0p5_p1p40 n_hvt_w5_l0p5_p1p40 0 0 sky130_fd_pr__cap_var_hvt w=5 l=0.5
VB_hvt_w5_l0p5_p1p50 b_hvt_w5_l0p5_p1p50 0 dc 1.5
RB_hvt_w5_l0p5_p1p50 b_hvt_w5_l0p5_p1p50 n_hvt_w5_l0p5_p1p50 1e12
IA_hvt_w5_l0p5_p1p50 0 n_hvt_w5_l0p5_p1p50 dc 0 ac 1
X_hvt_w5_l0p5_p1p50 n_hvt_w5_l0p5_p1p50 0 0 sky130_fd_pr__cap_var_hvt w=5 l=0.5
VB_hvt_w5_l0p5_p1p60 b_hvt_w5_l0p5_p1p60 0 dc 1.6
RB_hvt_w5_l0p5_p1p60 b_hvt_w5_l0p5_p1p60 n_hvt_w5_l0p5_p1p60 1e12
IA_hvt_w5_l0p5_p1p60 0 n_hvt_w5_l0p5_p1p60 dc 0 ac 1
X_hvt_w5_l0p5_p1p60 n_hvt_w5_l0p5_p1p60 0 0 sky130_fd_pr__cap_var_hvt w=5 l=0.5
VB_hvt_w5_l0p5_p1p70 b_hvt_w5_l0p5_p1p70 0 dc 1.7
RB_hvt_w5_l0p5_p1p70 b_hvt_w5_l0p5_p1p70 n_hvt_w5_l0p5_p1p70 1e12
IA_hvt_w5_l0p5_p1p70 0 n_hvt_w5_l0p5_p1p70 dc 0 ac 1
X_hvt_w5_l0p5_p1p70 n_hvt_w5_l0p5_p1p70 0 0 sky130_fd_pr__cap_var_hvt w=5 l=0.5
VB_hvt_w5_l0p5_p1p80 b_hvt_w5_l0p5_p1p80 0 dc 1.8
RB_hvt_w5_l0p5_p1p80 b_hvt_w5_l0p5_p1p80 n_hvt_w5_l0p5_p1p80 1e12
IA_hvt_w5_l0p5_p1p80 0 n_hvt_w5_l0p5_p1p80 dc 0 ac 1
X_hvt_w5_l0p5_p1p80 n_hvt_w5_l0p5_p1p80 0 0 sky130_fd_pr__cap_var_hvt w=5 l=0.5
VB_hvt_w5_l0p5_p1p90 b_hvt_w5_l0p5_p1p90 0 dc 1.9
RB_hvt_w5_l0p5_p1p90 b_hvt_w5_l0p5_p1p90 n_hvt_w5_l0p5_p1p90 1e12
IA_hvt_w5_l0p5_p1p90 0 n_hvt_w5_l0p5_p1p90 dc 0 ac 1
X_hvt_w5_l0p5_p1p90 n_hvt_w5_l0p5_p1p90 0 0 sky130_fd_pr__cap_var_hvt w=5 l=0.5
VB_hvt_w5_l0p5_p2p00 b_hvt_w5_l0p5_p2p00 0 dc 2.0
RB_hvt_w5_l0p5_p2p00 b_hvt_w5_l0p5_p2p00 n_hvt_w5_l0p5_p2p00 1e12
IA_hvt_w5_l0p5_p2p00 0 n_hvt_w5_l0p5_p2p00 dc 0 ac 1
X_hvt_w5_l0p5_p2p00 n_hvt_w5_l0p5_p2p00 0 0 sky130_fd_pr__cap_var_hvt w=5 l=0.5
VB_hvt_w5_l0p5_p2p10 b_hvt_w5_l0p5_p2p10 0 dc 2.1
RB_hvt_w5_l0p5_p2p10 b_hvt_w5_l0p5_p2p10 n_hvt_w5_l0p5_p2p10 1e12
IA_hvt_w5_l0p5_p2p10 0 n_hvt_w5_l0p5_p2p10 dc 0 ac 1
X_hvt_w5_l0p5_p2p10 n_hvt_w5_l0p5_p2p10 0 0 sky130_fd_pr__cap_var_hvt w=5 l=0.5
VB_hvt_w5_l0p5_p2p20 b_hvt_w5_l0p5_p2p20 0 dc 2.2
RB_hvt_w5_l0p5_p2p20 b_hvt_w5_l0p5_p2p20 n_hvt_w5_l0p5_p2p20 1e12
IA_hvt_w5_l0p5_p2p20 0 n_hvt_w5_l0p5_p2p20 dc 0 ac 1
X_hvt_w5_l0p5_p2p20 n_hvt_w5_l0p5_p2p20 0 0 sky130_fd_pr__cap_var_hvt w=5 l=0.5
VB_hvt_w5_l0p5_p2p30 b_hvt_w5_l0p5_p2p30 0 dc 2.3
RB_hvt_w5_l0p5_p2p30 b_hvt_w5_l0p5_p2p30 n_hvt_w5_l0p5_p2p30 1e12
IA_hvt_w5_l0p5_p2p30 0 n_hvt_w5_l0p5_p2p30 dc 0 ac 1
X_hvt_w5_l0p5_p2p30 n_hvt_w5_l0p5_p2p30 0 0 sky130_fd_pr__cap_var_hvt w=5 l=0.5
VB_hvt_w10_l10_m2p30 b_hvt_w10_l10_m2p30 0 dc -2.3
RB_hvt_w10_l10_m2p30 b_hvt_w10_l10_m2p30 n_hvt_w10_l10_m2p30 1e12
IA_hvt_w10_l10_m2p30 0 n_hvt_w10_l10_m2p30 dc 0 ac 1
X_hvt_w10_l10_m2p30 n_hvt_w10_l10_m2p30 0 0 sky130_fd_pr__cap_var_hvt w=10 l=10
VB_hvt_w10_l10_m2p20 b_hvt_w10_l10_m2p20 0 dc -2.2
RB_hvt_w10_l10_m2p20 b_hvt_w10_l10_m2p20 n_hvt_w10_l10_m2p20 1e12
IA_hvt_w10_l10_m2p20 0 n_hvt_w10_l10_m2p20 dc 0 ac 1
X_hvt_w10_l10_m2p20 n_hvt_w10_l10_m2p20 0 0 sky130_fd_pr__cap_var_hvt w=10 l=10
VB_hvt_w10_l10_m2p10 b_hvt_w10_l10_m2p10 0 dc -2.1
RB_hvt_w10_l10_m2p10 b_hvt_w10_l10_m2p10 n_hvt_w10_l10_m2p10 1e12
IA_hvt_w10_l10_m2p10 0 n_hvt_w10_l10_m2p10 dc 0 ac 1
X_hvt_w10_l10_m2p10 n_hvt_w10_l10_m2p10 0 0 sky130_fd_pr__cap_var_hvt w=10 l=10
VB_hvt_w10_l10_m2p00 b_hvt_w10_l10_m2p00 0 dc -2.0
RB_hvt_w10_l10_m2p00 b_hvt_w10_l10_m2p00 n_hvt_w10_l10_m2p00 1e12
IA_hvt_w10_l10_m2p00 0 n_hvt_w10_l10_m2p00 dc 0 ac 1
X_hvt_w10_l10_m2p00 n_hvt_w10_l10_m2p00 0 0 sky130_fd_pr__cap_var_hvt w=10 l=10
VB_hvt_w10_l10_m1p90 b_hvt_w10_l10_m1p90 0 dc -1.9
RB_hvt_w10_l10_m1p90 b_hvt_w10_l10_m1p90 n_hvt_w10_l10_m1p90 1e12
IA_hvt_w10_l10_m1p90 0 n_hvt_w10_l10_m1p90 dc 0 ac 1
X_hvt_w10_l10_m1p90 n_hvt_w10_l10_m1p90 0 0 sky130_fd_pr__cap_var_hvt w=10 l=10
VB_hvt_w10_l10_m1p80 b_hvt_w10_l10_m1p80 0 dc -1.8
RB_hvt_w10_l10_m1p80 b_hvt_w10_l10_m1p80 n_hvt_w10_l10_m1p80 1e12
IA_hvt_w10_l10_m1p80 0 n_hvt_w10_l10_m1p80 dc 0 ac 1
X_hvt_w10_l10_m1p80 n_hvt_w10_l10_m1p80 0 0 sky130_fd_pr__cap_var_hvt w=10 l=10
VB_hvt_w10_l10_m1p70 b_hvt_w10_l10_m1p70 0 dc -1.7
RB_hvt_w10_l10_m1p70 b_hvt_w10_l10_m1p70 n_hvt_w10_l10_m1p70 1e12
IA_hvt_w10_l10_m1p70 0 n_hvt_w10_l10_m1p70 dc 0 ac 1
X_hvt_w10_l10_m1p70 n_hvt_w10_l10_m1p70 0 0 sky130_fd_pr__cap_var_hvt w=10 l=10
VB_hvt_w10_l10_m1p60 b_hvt_w10_l10_m1p60 0 dc -1.6
RB_hvt_w10_l10_m1p60 b_hvt_w10_l10_m1p60 n_hvt_w10_l10_m1p60 1e12
IA_hvt_w10_l10_m1p60 0 n_hvt_w10_l10_m1p60 dc 0 ac 1
X_hvt_w10_l10_m1p60 n_hvt_w10_l10_m1p60 0 0 sky130_fd_pr__cap_var_hvt w=10 l=10
VB_hvt_w10_l10_m1p50 b_hvt_w10_l10_m1p50 0 dc -1.5
RB_hvt_w10_l10_m1p50 b_hvt_w10_l10_m1p50 n_hvt_w10_l10_m1p50 1e12
IA_hvt_w10_l10_m1p50 0 n_hvt_w10_l10_m1p50 dc 0 ac 1
X_hvt_w10_l10_m1p50 n_hvt_w10_l10_m1p50 0 0 sky130_fd_pr__cap_var_hvt w=10 l=10
VB_hvt_w10_l10_m1p40 b_hvt_w10_l10_m1p40 0 dc -1.4
RB_hvt_w10_l10_m1p40 b_hvt_w10_l10_m1p40 n_hvt_w10_l10_m1p40 1e12
IA_hvt_w10_l10_m1p40 0 n_hvt_w10_l10_m1p40 dc 0 ac 1
X_hvt_w10_l10_m1p40 n_hvt_w10_l10_m1p40 0 0 sky130_fd_pr__cap_var_hvt w=10 l=10
VB_hvt_w10_l10_m1p30 b_hvt_w10_l10_m1p30 0 dc -1.3
RB_hvt_w10_l10_m1p30 b_hvt_w10_l10_m1p30 n_hvt_w10_l10_m1p30 1e12
IA_hvt_w10_l10_m1p30 0 n_hvt_w10_l10_m1p30 dc 0 ac 1
X_hvt_w10_l10_m1p30 n_hvt_w10_l10_m1p30 0 0 sky130_fd_pr__cap_var_hvt w=10 l=10
VB_hvt_w10_l10_m1p20 b_hvt_w10_l10_m1p20 0 dc -1.2
RB_hvt_w10_l10_m1p20 b_hvt_w10_l10_m1p20 n_hvt_w10_l10_m1p20 1e12
IA_hvt_w10_l10_m1p20 0 n_hvt_w10_l10_m1p20 dc 0 ac 1
X_hvt_w10_l10_m1p20 n_hvt_w10_l10_m1p20 0 0 sky130_fd_pr__cap_var_hvt w=10 l=10
VB_hvt_w10_l10_m1p10 b_hvt_w10_l10_m1p10 0 dc -1.1
RB_hvt_w10_l10_m1p10 b_hvt_w10_l10_m1p10 n_hvt_w10_l10_m1p10 1e12
IA_hvt_w10_l10_m1p10 0 n_hvt_w10_l10_m1p10 dc 0 ac 1
X_hvt_w10_l10_m1p10 n_hvt_w10_l10_m1p10 0 0 sky130_fd_pr__cap_var_hvt w=10 l=10
VB_hvt_w10_l10_m1p00 b_hvt_w10_l10_m1p00 0 dc -1.0
RB_hvt_w10_l10_m1p00 b_hvt_w10_l10_m1p00 n_hvt_w10_l10_m1p00 1e12
IA_hvt_w10_l10_m1p00 0 n_hvt_w10_l10_m1p00 dc 0 ac 1
X_hvt_w10_l10_m1p00 n_hvt_w10_l10_m1p00 0 0 sky130_fd_pr__cap_var_hvt w=10 l=10
VB_hvt_w10_l10_m0p90 b_hvt_w10_l10_m0p90 0 dc -0.9
RB_hvt_w10_l10_m0p90 b_hvt_w10_l10_m0p90 n_hvt_w10_l10_m0p90 1e12
IA_hvt_w10_l10_m0p90 0 n_hvt_w10_l10_m0p90 dc 0 ac 1
X_hvt_w10_l10_m0p90 n_hvt_w10_l10_m0p90 0 0 sky130_fd_pr__cap_var_hvt w=10 l=10
VB_hvt_w10_l10_m0p80 b_hvt_w10_l10_m0p80 0 dc -0.8
RB_hvt_w10_l10_m0p80 b_hvt_w10_l10_m0p80 n_hvt_w10_l10_m0p80 1e12
IA_hvt_w10_l10_m0p80 0 n_hvt_w10_l10_m0p80 dc 0 ac 1
X_hvt_w10_l10_m0p80 n_hvt_w10_l10_m0p80 0 0 sky130_fd_pr__cap_var_hvt w=10 l=10
VB_hvt_w10_l10_m0p70 b_hvt_w10_l10_m0p70 0 dc -0.7
RB_hvt_w10_l10_m0p70 b_hvt_w10_l10_m0p70 n_hvt_w10_l10_m0p70 1e12
IA_hvt_w10_l10_m0p70 0 n_hvt_w10_l10_m0p70 dc 0 ac 1
X_hvt_w10_l10_m0p70 n_hvt_w10_l10_m0p70 0 0 sky130_fd_pr__cap_var_hvt w=10 l=10
VB_hvt_w10_l10_m0p60 b_hvt_w10_l10_m0p60 0 dc -0.6
RB_hvt_w10_l10_m0p60 b_hvt_w10_l10_m0p60 n_hvt_w10_l10_m0p60 1e12
IA_hvt_w10_l10_m0p60 0 n_hvt_w10_l10_m0p60 dc 0 ac 1
X_hvt_w10_l10_m0p60 n_hvt_w10_l10_m0p60 0 0 sky130_fd_pr__cap_var_hvt w=10 l=10
VB_hvt_w10_l10_m0p50 b_hvt_w10_l10_m0p50 0 dc -0.5
RB_hvt_w10_l10_m0p50 b_hvt_w10_l10_m0p50 n_hvt_w10_l10_m0p50 1e12
IA_hvt_w10_l10_m0p50 0 n_hvt_w10_l10_m0p50 dc 0 ac 1
X_hvt_w10_l10_m0p50 n_hvt_w10_l10_m0p50 0 0 sky130_fd_pr__cap_var_hvt w=10 l=10
VB_hvt_w10_l10_m0p40 b_hvt_w10_l10_m0p40 0 dc -0.4
RB_hvt_w10_l10_m0p40 b_hvt_w10_l10_m0p40 n_hvt_w10_l10_m0p40 1e12
IA_hvt_w10_l10_m0p40 0 n_hvt_w10_l10_m0p40 dc 0 ac 1
X_hvt_w10_l10_m0p40 n_hvt_w10_l10_m0p40 0 0 sky130_fd_pr__cap_var_hvt w=10 l=10
VB_hvt_w10_l10_m0p30 b_hvt_w10_l10_m0p30 0 dc -0.3
RB_hvt_w10_l10_m0p30 b_hvt_w10_l10_m0p30 n_hvt_w10_l10_m0p30 1e12
IA_hvt_w10_l10_m0p30 0 n_hvt_w10_l10_m0p30 dc 0 ac 1
X_hvt_w10_l10_m0p30 n_hvt_w10_l10_m0p30 0 0 sky130_fd_pr__cap_var_hvt w=10 l=10
VB_hvt_w10_l10_m0p20 b_hvt_w10_l10_m0p20 0 dc -0.2
RB_hvt_w10_l10_m0p20 b_hvt_w10_l10_m0p20 n_hvt_w10_l10_m0p20 1e12
IA_hvt_w10_l10_m0p20 0 n_hvt_w10_l10_m0p20 dc 0 ac 1
X_hvt_w10_l10_m0p20 n_hvt_w10_l10_m0p20 0 0 sky130_fd_pr__cap_var_hvt w=10 l=10
VB_hvt_w10_l10_m0p10 b_hvt_w10_l10_m0p10 0 dc -0.1
RB_hvt_w10_l10_m0p10 b_hvt_w10_l10_m0p10 n_hvt_w10_l10_m0p10 1e12
IA_hvt_w10_l10_m0p10 0 n_hvt_w10_l10_m0p10 dc 0 ac 1
X_hvt_w10_l10_m0p10 n_hvt_w10_l10_m0p10 0 0 sky130_fd_pr__cap_var_hvt w=10 l=10
VB_hvt_w10_l10_p0p00 b_hvt_w10_l10_p0p00 0 dc 0.0
RB_hvt_w10_l10_p0p00 b_hvt_w10_l10_p0p00 n_hvt_w10_l10_p0p00 1e12
IA_hvt_w10_l10_p0p00 0 n_hvt_w10_l10_p0p00 dc 0 ac 1
X_hvt_w10_l10_p0p00 n_hvt_w10_l10_p0p00 0 0 sky130_fd_pr__cap_var_hvt w=10 l=10
VB_hvt_w10_l10_p0p10 b_hvt_w10_l10_p0p10 0 dc 0.1
RB_hvt_w10_l10_p0p10 b_hvt_w10_l10_p0p10 n_hvt_w10_l10_p0p10 1e12
IA_hvt_w10_l10_p0p10 0 n_hvt_w10_l10_p0p10 dc 0 ac 1
X_hvt_w10_l10_p0p10 n_hvt_w10_l10_p0p10 0 0 sky130_fd_pr__cap_var_hvt w=10 l=10
VB_hvt_w10_l10_p0p20 b_hvt_w10_l10_p0p20 0 dc 0.2
RB_hvt_w10_l10_p0p20 b_hvt_w10_l10_p0p20 n_hvt_w10_l10_p0p20 1e12
IA_hvt_w10_l10_p0p20 0 n_hvt_w10_l10_p0p20 dc 0 ac 1
X_hvt_w10_l10_p0p20 n_hvt_w10_l10_p0p20 0 0 sky130_fd_pr__cap_var_hvt w=10 l=10
VB_hvt_w10_l10_p0p30 b_hvt_w10_l10_p0p30 0 dc 0.3
RB_hvt_w10_l10_p0p30 b_hvt_w10_l10_p0p30 n_hvt_w10_l10_p0p30 1e12
IA_hvt_w10_l10_p0p30 0 n_hvt_w10_l10_p0p30 dc 0 ac 1
X_hvt_w10_l10_p0p30 n_hvt_w10_l10_p0p30 0 0 sky130_fd_pr__cap_var_hvt w=10 l=10
VB_hvt_w10_l10_p0p40 b_hvt_w10_l10_p0p40 0 dc 0.4
RB_hvt_w10_l10_p0p40 b_hvt_w10_l10_p0p40 n_hvt_w10_l10_p0p40 1e12
IA_hvt_w10_l10_p0p40 0 n_hvt_w10_l10_p0p40 dc 0 ac 1
X_hvt_w10_l10_p0p40 n_hvt_w10_l10_p0p40 0 0 sky130_fd_pr__cap_var_hvt w=10 l=10
VB_hvt_w10_l10_p0p50 b_hvt_w10_l10_p0p50 0 dc 0.5
RB_hvt_w10_l10_p0p50 b_hvt_w10_l10_p0p50 n_hvt_w10_l10_p0p50 1e12
IA_hvt_w10_l10_p0p50 0 n_hvt_w10_l10_p0p50 dc 0 ac 1
X_hvt_w10_l10_p0p50 n_hvt_w10_l10_p0p50 0 0 sky130_fd_pr__cap_var_hvt w=10 l=10
VB_hvt_w10_l10_p0p60 b_hvt_w10_l10_p0p60 0 dc 0.6
RB_hvt_w10_l10_p0p60 b_hvt_w10_l10_p0p60 n_hvt_w10_l10_p0p60 1e12
IA_hvt_w10_l10_p0p60 0 n_hvt_w10_l10_p0p60 dc 0 ac 1
X_hvt_w10_l10_p0p60 n_hvt_w10_l10_p0p60 0 0 sky130_fd_pr__cap_var_hvt w=10 l=10
VB_hvt_w10_l10_p0p70 b_hvt_w10_l10_p0p70 0 dc 0.7
RB_hvt_w10_l10_p0p70 b_hvt_w10_l10_p0p70 n_hvt_w10_l10_p0p70 1e12
IA_hvt_w10_l10_p0p70 0 n_hvt_w10_l10_p0p70 dc 0 ac 1
X_hvt_w10_l10_p0p70 n_hvt_w10_l10_p0p70 0 0 sky130_fd_pr__cap_var_hvt w=10 l=10
VB_hvt_w10_l10_p0p80 b_hvt_w10_l10_p0p80 0 dc 0.8
RB_hvt_w10_l10_p0p80 b_hvt_w10_l10_p0p80 n_hvt_w10_l10_p0p80 1e12
IA_hvt_w10_l10_p0p80 0 n_hvt_w10_l10_p0p80 dc 0 ac 1
X_hvt_w10_l10_p0p80 n_hvt_w10_l10_p0p80 0 0 sky130_fd_pr__cap_var_hvt w=10 l=10
VB_hvt_w10_l10_p0p90 b_hvt_w10_l10_p0p90 0 dc 0.9
RB_hvt_w10_l10_p0p90 b_hvt_w10_l10_p0p90 n_hvt_w10_l10_p0p90 1e12
IA_hvt_w10_l10_p0p90 0 n_hvt_w10_l10_p0p90 dc 0 ac 1
X_hvt_w10_l10_p0p90 n_hvt_w10_l10_p0p90 0 0 sky130_fd_pr__cap_var_hvt w=10 l=10
VB_hvt_w10_l10_p1p00 b_hvt_w10_l10_p1p00 0 dc 1.0
RB_hvt_w10_l10_p1p00 b_hvt_w10_l10_p1p00 n_hvt_w10_l10_p1p00 1e12
IA_hvt_w10_l10_p1p00 0 n_hvt_w10_l10_p1p00 dc 0 ac 1
X_hvt_w10_l10_p1p00 n_hvt_w10_l10_p1p00 0 0 sky130_fd_pr__cap_var_hvt w=10 l=10
VB_hvt_w10_l10_p1p10 b_hvt_w10_l10_p1p10 0 dc 1.1
RB_hvt_w10_l10_p1p10 b_hvt_w10_l10_p1p10 n_hvt_w10_l10_p1p10 1e12
IA_hvt_w10_l10_p1p10 0 n_hvt_w10_l10_p1p10 dc 0 ac 1
X_hvt_w10_l10_p1p10 n_hvt_w10_l10_p1p10 0 0 sky130_fd_pr__cap_var_hvt w=10 l=10
VB_hvt_w10_l10_p1p20 b_hvt_w10_l10_p1p20 0 dc 1.2
RB_hvt_w10_l10_p1p20 b_hvt_w10_l10_p1p20 n_hvt_w10_l10_p1p20 1e12
IA_hvt_w10_l10_p1p20 0 n_hvt_w10_l10_p1p20 dc 0 ac 1
X_hvt_w10_l10_p1p20 n_hvt_w10_l10_p1p20 0 0 sky130_fd_pr__cap_var_hvt w=10 l=10
VB_hvt_w10_l10_p1p30 b_hvt_w10_l10_p1p30 0 dc 1.3
RB_hvt_w10_l10_p1p30 b_hvt_w10_l10_p1p30 n_hvt_w10_l10_p1p30 1e12
IA_hvt_w10_l10_p1p30 0 n_hvt_w10_l10_p1p30 dc 0 ac 1
X_hvt_w10_l10_p1p30 n_hvt_w10_l10_p1p30 0 0 sky130_fd_pr__cap_var_hvt w=10 l=10
VB_hvt_w10_l10_p1p40 b_hvt_w10_l10_p1p40 0 dc 1.4
RB_hvt_w10_l10_p1p40 b_hvt_w10_l10_p1p40 n_hvt_w10_l10_p1p40 1e12
IA_hvt_w10_l10_p1p40 0 n_hvt_w10_l10_p1p40 dc 0 ac 1
X_hvt_w10_l10_p1p40 n_hvt_w10_l10_p1p40 0 0 sky130_fd_pr__cap_var_hvt w=10 l=10
VB_hvt_w10_l10_p1p50 b_hvt_w10_l10_p1p50 0 dc 1.5
RB_hvt_w10_l10_p1p50 b_hvt_w10_l10_p1p50 n_hvt_w10_l10_p1p50 1e12
IA_hvt_w10_l10_p1p50 0 n_hvt_w10_l10_p1p50 dc 0 ac 1
X_hvt_w10_l10_p1p50 n_hvt_w10_l10_p1p50 0 0 sky130_fd_pr__cap_var_hvt w=10 l=10
VB_hvt_w10_l10_p1p60 b_hvt_w10_l10_p1p60 0 dc 1.6
RB_hvt_w10_l10_p1p60 b_hvt_w10_l10_p1p60 n_hvt_w10_l10_p1p60 1e12
IA_hvt_w10_l10_p1p60 0 n_hvt_w10_l10_p1p60 dc 0 ac 1
X_hvt_w10_l10_p1p60 n_hvt_w10_l10_p1p60 0 0 sky130_fd_pr__cap_var_hvt w=10 l=10
VB_hvt_w10_l10_p1p70 b_hvt_w10_l10_p1p70 0 dc 1.7
RB_hvt_w10_l10_p1p70 b_hvt_w10_l10_p1p70 n_hvt_w10_l10_p1p70 1e12
IA_hvt_w10_l10_p1p70 0 n_hvt_w10_l10_p1p70 dc 0 ac 1
X_hvt_w10_l10_p1p70 n_hvt_w10_l10_p1p70 0 0 sky130_fd_pr__cap_var_hvt w=10 l=10
VB_hvt_w10_l10_p1p80 b_hvt_w10_l10_p1p80 0 dc 1.8
RB_hvt_w10_l10_p1p80 b_hvt_w10_l10_p1p80 n_hvt_w10_l10_p1p80 1e12
IA_hvt_w10_l10_p1p80 0 n_hvt_w10_l10_p1p80 dc 0 ac 1
X_hvt_w10_l10_p1p80 n_hvt_w10_l10_p1p80 0 0 sky130_fd_pr__cap_var_hvt w=10 l=10
VB_hvt_w10_l10_p1p90 b_hvt_w10_l10_p1p90 0 dc 1.9
RB_hvt_w10_l10_p1p90 b_hvt_w10_l10_p1p90 n_hvt_w10_l10_p1p90 1e12
IA_hvt_w10_l10_p1p90 0 n_hvt_w10_l10_p1p90 dc 0 ac 1
X_hvt_w10_l10_p1p90 n_hvt_w10_l10_p1p90 0 0 sky130_fd_pr__cap_var_hvt w=10 l=10
VB_hvt_w10_l10_p2p00 b_hvt_w10_l10_p2p00 0 dc 2.0
RB_hvt_w10_l10_p2p00 b_hvt_w10_l10_p2p00 n_hvt_w10_l10_p2p00 1e12
IA_hvt_w10_l10_p2p00 0 n_hvt_w10_l10_p2p00 dc 0 ac 1
X_hvt_w10_l10_p2p00 n_hvt_w10_l10_p2p00 0 0 sky130_fd_pr__cap_var_hvt w=10 l=10
VB_hvt_w10_l10_p2p10 b_hvt_w10_l10_p2p10 0 dc 2.1
RB_hvt_w10_l10_p2p10 b_hvt_w10_l10_p2p10 n_hvt_w10_l10_p2p10 1e12
IA_hvt_w10_l10_p2p10 0 n_hvt_w10_l10_p2p10 dc 0 ac 1
X_hvt_w10_l10_p2p10 n_hvt_w10_l10_p2p10 0 0 sky130_fd_pr__cap_var_hvt w=10 l=10
VB_hvt_w10_l10_p2p20 b_hvt_w10_l10_p2p20 0 dc 2.2
RB_hvt_w10_l10_p2p20 b_hvt_w10_l10_p2p20 n_hvt_w10_l10_p2p20 1e12
IA_hvt_w10_l10_p2p20 0 n_hvt_w10_l10_p2p20 dc 0 ac 1
X_hvt_w10_l10_p2p20 n_hvt_w10_l10_p2p20 0 0 sky130_fd_pr__cap_var_hvt w=10 l=10
VB_hvt_w10_l10_p2p30 b_hvt_w10_l10_p2p30 0 dc 2.3
RB_hvt_w10_l10_p2p30 b_hvt_w10_l10_p2p30 n_hvt_w10_l10_p2p30 1e12
IA_hvt_w10_l10_p2p30 0 n_hvt_w10_l10_p2p30 dc 0 ac 1
X_hvt_w10_l10_p2p30 n_hvt_w10_l10_p2p30 0 0 sky130_fd_pr__cap_var_hvt w=10 l=10
