* klt sim -- generated corner deck, do not edit
.lib $PDK_ROOT/sky130A/libs.tech/combined/sky130.lib.spice tt
.include layout/cap-study/20261011-094917-7a4e0cc/op/requests/v3.30_0ma.spice
.temp 27.0
.meas tran v_vout avg v(vout) from=199m to=200m
.meas tran v_ea_cz avg v(xldo.ea_cz) from=199m to=200m
.meas tran v_vin avg v(vin) from=199m to=200m
.meas tran v_cl_cmp avg v(xldo.cl_cmp) from=199m to=200m
.meas tran v_ss avg v(xldo.ss) from=199m to=200m
.meas tran v_ts_cmp avg v(xldo.ts_cmp) from=199m to=200m
.control
save all
tran 10u 200m uic
quit
.endc
.end
