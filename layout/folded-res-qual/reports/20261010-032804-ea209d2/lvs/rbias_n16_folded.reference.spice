* Reference: the UNSPLIT schematic resistor (issue #253). R/A/P from the
* same deck constants gen-ldo-reference-netlist.py uses.
.SUBCKT rbias_n16_folded A B SUB
R1 A B 1160477.005147 res_high_po L=1500U W=0.42U A=630P P=3000.84U
.ENDS rbias_n16_folded
