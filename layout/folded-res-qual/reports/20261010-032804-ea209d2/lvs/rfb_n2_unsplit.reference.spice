* Reference: the UNSPLIT schematic resistor (issue #253). R/A/P from the
* same deck constants gen-ldo-reference-netlist.py uses.
.SUBCKT rfb_n2_unsplit A B SUB
R1 A B 857142.857143 res_xhigh_po L=180U W=0.42U A=75.6P P=360.84U
.ENDS rfb_n2_unsplit
