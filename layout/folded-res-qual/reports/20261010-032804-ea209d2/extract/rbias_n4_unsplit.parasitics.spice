* extracted by klt extract --deck sky130
* parasitic model (--parasitics):
* - capacitance: net-to-ground for every net's own (non-coupled) area/perimeter, plus net-to-net for the vertical-overlap coupling `coupling` describes below -- a coupled net pair gets a direct capacitor between their two hub nodes, not just capacitors to the deck's ground/substrate net
* - coupling: vertical overlap (crossover) unconditionally -- where one net's conductor on an adjacent metal level sits directly over another *distinct* net's conductor, that overlap area is charged between the two nets instead of to ground (issue #760) -- plus lateral (same-layer, sidewall) coupling, but only for a net pair naming one of the caller's declared `--critical-net` nets (issue #976): facing-edge length within that layer's own minimum-spacing lookback is charged between the two nets, *additively* (not deducted from either net's substrate fringe term, unlike the vertical case -- a known simplification). Any same-layer pair with neither side named `--critical-net`, and fringe shielding in general, are still not modelled
* - resistance: single lumped series resistance per net, distributed as a star across that net's device terminals (issue #592) -- not a per-segment, distributed RC ladder, *unless* `--distributed-rc` names this net via `--critical-net` (issue #977, Epic #709 Phase 2b): then the net's terminals are ordered along their approximate physical spread and its total R/C is broken into a chain of per-segment resistors (segment length proportional to inter-terminal distance) with a ground capacitor at each terminal node (proportional to its adjacent segment length/2), instead of one star hub -- still an approximation (terminal position is a device-placement proxy, not true per-segment routing geometry), but a strictly finer-grained one than the single-hub star
* - frequency: quasi-static -- one frequency-independent R and C per net; no skin effect, no distributed transmission-line behavior
.GLOBAL vsubs

* cell rbias_n4_unsplit
* pin A
* pin B
* pin SUB
.SUBCKT rbias_n4_unsplit A B SUB
* device instance $1 r0 *1 750.42,0.21 res_high_po
X$1 A__t0 B__t0 SUB__t0 res_high_po r=1160477.00515 L=1500U W=0.42U
* device instance A_t0 r0 *1 0,0
RA_t0 A__t0 A 61
* device instance A r0 *1 0,0
CA A vsubs 1.86631e-16
* device instance B_t0 r0 *1 0,0
RB_t0 B__t0 B 61
* device instance B r0 *1 0,0
CB B vsubs 1.86631e-16
* device instance SUB_t0 r0 *1 0,0
RSUB_t0 SUB__t0 SUB 12.8
* device instance SUB r0 *1 0,0
CSUB SUB vsubs 7.4903e-17
* device instance vsubs_dctie r0 *1 0,0
Rvsubs_dctie vsubs 0 1e+12
.ENDS rbias_n4_unsplit
