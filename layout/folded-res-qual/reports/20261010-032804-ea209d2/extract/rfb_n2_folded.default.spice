* extracted by klt extract --deck sky130

* cell rfb_n2_folded
* pin A
* pin B
* pin SUB
.SUBCKT rfb_n2_folded A B SUB
* device instance $1 r0 *1 45.42,0.21 res_xhigh_po
X$1 A \$2 SUB res_xhigh_po r=428571.428571 L=90U W=0.42U
* device instance $2 r0 *1 45.42,1.03 res_xhigh_po
X$2 B \$2 SUB res_xhigh_po r=428571.428571 L=90U W=0.42U
.ENDS rfb_n2_folded
