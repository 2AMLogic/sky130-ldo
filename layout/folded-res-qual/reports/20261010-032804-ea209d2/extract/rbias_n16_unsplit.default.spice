* extracted by klt extract --deck sky130

* cell rbias_n16_unsplit
* pin A
* pin B
* pin SUB
.SUBCKT rbias_n16_unsplit A B SUB
* device instance $1 r0 *1 750.42,0.21 res_high_po
X$1 A B SUB res_high_po r=1160477.00515 L=1500U W=0.42U
.ENDS rbias_n16_unsplit
