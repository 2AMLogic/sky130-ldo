* extracted by klt extract --deck sky130

* cell rfb_n2_unsplit
* pin A
* pin B
* pin SUB
.SUBCKT rfb_n2_unsplit A B SUB
* device instance $1 r0 *1 90.42,0.21 res_xhigh_po
X$1 A B SUB res_xhigh_po r=857142.857143 L=180U W=0.42U
.ENDS rfb_n2_unsplit
