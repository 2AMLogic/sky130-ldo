* one-device repro: xschem 3.4.4 normalized geometry shape on a g5v0d10v5 instance
.lib /home/ubuntu/.volare/sky130A/libs.tech/combined/sky130.lib.spice tt
VD d 0 1.8
VG g 0 1.8
XM1 d g 0 0 sky130_fd_pr__nfet_g5v0d10v5 L=1 W=4 nf=1 ad=1.16 as=1.16
+ pd=8.58 ps=8.58
+ nrd=0.0725 nrs=0.0725 sa=0 sb=0 sd=0 mult=1 m=1
.op
.end
