* extracted by klt extract --deck sky130
* parasitic model (--parasitics):
* - capacitance: net-to-ground for every net's own (non-coupled) area/perimeter, plus net-to-net for the vertical-overlap coupling `coupling` describes below -- a coupled net pair gets a direct capacitor between their two hub nodes, not just capacitors to the deck's ground/substrate net
* - coupling: vertical overlap (crossover) unconditionally -- where one net's conductor on an adjacent metal level sits directly over another *distinct* net's conductor, that overlap area is charged between the two nets instead of to ground (issue #760) -- plus lateral (same-layer, sidewall) coupling, but only for a net pair naming one of the caller's declared `--critical-net` nets (issue #976): facing-edge length within that layer's own minimum-spacing lookback is charged between the two nets, *additively* (not deducted from either net's substrate fringe term, unlike the vertical case -- a known simplification). Any same-layer pair with neither side named `--critical-net`, and fringe shielding in general, are still not modelled
* - resistance: single lumped series resistance per net, distributed as a star across that net's device terminals (issue #592) -- not a per-segment, distributed RC ladder, *unless* `--distributed-rc` names this net via `--critical-net` (issue #977, Epic #709 Phase 2b): then the net's terminals are ordered along their approximate physical spread and its total R/C is broken into a chain of per-segment resistors (segment length proportional to inter-terminal distance) with a ground capacitor at each terminal node (proportional to its adjacent segment length/2), instead of one star hub -- still an approximation (terminal position is a device-placement proxy, not true per-segment routing geometry), but a strictly finer-grained one than the single-hub star
* - frequency: quasi-static -- one frequency-independent R and C per net; no skin effect, no distributed transmission-line behavior
.GLOBAL vsubs

* cell ldo_core
* pin 0
* pin AMP_ENN
* pin BIASP
* pin BIAS_ENN
* pin CL_CMP
* pin CL_SNS
* pin EA_CZ
* pin EA_D1
* pin EA_D2
* pin EA_OUT
* pin EA_TAIL
* pin EN
* pin ENB
* pin FB
* pin NB
* pin N_FBB
* pin PB
* pin SS
* pin TC_D1
* pin TC_TAIL
* pin TS_CMP
* pin TS_HYS
* pin TS_MID
* pin TS_REF
* pin TS_SNS
* pin VIN
* pin VOUT
* pin VREF
.SUBCKT ldo_core 0 AMP_ENN BIASP BIAS_ENN CL_CMP CL_SNS EA_CZ EA_D1 EA_D2
+ EA_OUT EA_TAIL EN ENB FB NB N_FBB PB SS TC_D1 TC_TAIL TS_CMP TS_HYS TS_MID
+ TS_REF TS_SNS VIN VOUT VREF
* device instance $1 r0 *1 2197.73,0.36 nfet
X$1 TS_REF__t0 TS_REF__t1 AMP_ENN__t3 0__t5 sky130_fd_pr__nfet_g5v0d10v5 L=2
+ W=0.42 AS=0.1764 AD=0.1764 PS=1.68 PD=1.68
* device instance $2 r0 *1 2175.42,0.65 nfet
X$2 ENB__t0 EN__t1 0__t24 0__t6 sky130_fd_pr__nfet_g5v0d10v5 L=0.5 W=1 AS=0.42
+ AD=0.42 PS=2.84 PD=2.84
* device instance $3 r0 *1 2202.37,0.65 nfet
X$3 TC_TAIL__t0 NB__t3 AMP_ENN__t4 0__t7 sky130_fd_pr__nfet_g5v0d10v5 L=1 W=1
+ AS=0.42 AD=0.42 PS=2.84 PD=2.84
* device instance $4 r0 *1 2171.53,0.95 nfet
X$4 CL_CMP__t0 CL_SNS__t2 AMP_ENN__t2 0__t8 sky130_fd_pr__nfet_g5v0d10v5 L=1
+ W=1.6 AS=0.672 AD=0.672 PS=4.04 PD=4.04
* device instance $5 r0 *1 2179.06,1.15 nfet
X$5 SS__t0 ENB__t1 0__t25 0__t9 sky130_fd_pr__nfet_g5v0d10v5 L=0.5 W=2 AS=0.84
+ AD=0.84 PS=4.84 PD=4.84
* device instance $6 r0 *1 2123.27,2.15 nfet
X$6 NB__t1 NB__t2 BIAS_ENN__t0 0__t10 sky130_fd_pr__nfet_g5v0d10v5 L=1 W=4
+ AS=1.68 AD=1.68 PS=8.84 PD=8.84
* device instance $7 r0 *1 2131.05,2.15 nfet
X$7 BIASP__t9 NB__t4 BIAS_ENN__t2 0__t11 sky130_fd_pr__nfet_g5v0d10v5 L=1 W=4
+ AS=1.68 AD=1.68 PS=8.84 PD=8.84
* device instance $8 r0 *1 2127.16,5.15 nfet
X$8 BIAS_ENN__t1 EN__t0 0__t23 0__t12 sky130_fd_pr__nfet_g5v0d10v5 L=0.5 W=10
+ AS=4.2 AD=4.2 PS=20.84 PD=20.84
* device instance $9 r0 *1 2134.94,5.15 nfet
X$9 AMP_ENN__t9 EN__t8 0__t26 0__t13 sky130_fd_pr__nfet_g5v0d10v5 L=0.5 W=10
+ AS=4.2 AD=4.2 PS=20.84 PD=20.84
* device instance $10 r0 *1 2140.33,5.15 nfet
X$10 EA_D1__t3 EA_D1__t0 AMP_ENN__t0 0__t14 sky130_fd_pr__nfet_g5v0d10v5 L=4
+ W=10 AS=4.2 AD=4.2 PS=20.84 PD=20.84
* device instance $11 r0 *1 2147.47,5.15 nfet
X$11 EA_OUT__t1 EA_D1__t2 AMP_ENN__t6 0__t15 sky130_fd_pr__nfet_g5v0d10v5 L=4
+ W=10 AS=4.2 AD=4.2 PS=20.84 PD=20.84
* device instance $12 r0 *1 2154.61,5.15 nfet
X$12 EA_D2__t4 EA_D2__t2 AMP_ENN__t7 0__t16 sky130_fd_pr__nfet_g5v0d10v5 L=4
+ W=10 AS=4.2 AD=4.2 PS=20.84 PD=20.84
* device instance $13 r0 *1 2161.75,5.15 nfet
X$13 PB__t4 EA_D2__t3 AMP_ENN__t8 0__t17 sky130_fd_pr__nfet_g5v0d10v5 L=4 W=10
+ AS=4.2 AD=4.2 PS=20.84 PD=20.84
* device instance $14 r0 *1 2207.01,5.15 nfet
X$14 TC_D1__t0 TS_SNS__t0 TC_TAIL__t1 0__t18 sky130_fd_pr__nfet_g5v0d10v5 L=2
+ W=10 AS=4.2 AD=4.2 PS=20.84 PD=20.84
* device instance $15 r0 *1 2212.15,5.15 nfet
X$15 TS_CMP__t4 TS_REF__t4 TC_TAIL__t2 0__t19 sky130_fd_pr__nfet_g5v0d10v5 L=2
+ W=10 AS=4.2 AD=4.2 PS=20.84 PD=20.84
* device instance $16 r0 *1 2167.39,10.15 nfet
X$16 CL_SNS__t0 CL_SNS__t1 AMP_ENN__t1 0__t20 sky130_fd_pr__nfet_g5v0d10v5 L=1
+ W=20 AS=8.4 AD=8.4 PS=40.84 PD=40.84
* device instance $17 r0 *1 2184.45,40.15 nfet
X$17 TS_SNS__t3 TS_SNS__t2 TS_MID__t0 0__t21 sky130_fd_pr__nfet_g5v0d10v5 L=4
+ W=80 AS=33.6 AD=33.6 PS=160.84 PD=160.84
* device instance $18 r0 *1 2191.59,40.15 nfet
X$18 TS_MID__t1 TS_MID__t2 AMP_ENN__t5 0__t22 sky130_fd_pr__nfet_g5v0d10v5 L=4
+ W=80 AS=33.6 AD=33.6 PS=160.84 PD=160.84
* device instance $19 r0 *1 2228.79,5.15 pfet
X$19 BIASP__t0 BIASP__t1 VIN__t2 VIN__t1 sky130_fd_pr__pfet_g5v0d10v5 L=1 W=10
+ AS=4.2 AD=4.2 PS=20.84 PD=20.84
* device instance $20 r0 *1 2232.68,5.15 pfet
X$20 BIASP__t8 EN__t2 VIN__t4 VIN__t3 sky130_fd_pr__pfet_g5v0d10v5 L=0.5 W=10
+ AS=4.2 AD=4.2 PS=20.84 PD=20.84
* device instance $21 r0 *1 2236.32,5.15 pfet
X$21 EA_OUT__t2 EN__t7 VIN__t141 VIN__t142 sky130_fd_pr__pfet_g5v0d10v5 L=0.5
+ W=10 AS=4.2 AD=4.2 PS=20.84 PD=20.84
* device instance $22 r0 *1 2239.96,1.15 pfet
X$22 PB__t0 EN__t3 VIN__t6 VIN__t5 sky130_fd_pr__pfet_g5v0d10v5 L=0.5 W=2
+ AS=0.84 AD=0.84 PS=4.84 PD=4.84
* device instance $23 r0 *1 2243.6,1.15 pfet
X$23 CL_CMP__t2 EN__t4 VIN__t134 VIN__t137 sky130_fd_pr__pfet_g5v0d10v5 L=0.5
+ W=2 AS=0.84 AD=0.84 PS=4.84 PD=4.84
* device instance $24 r0 *1 2247.24,1.15 pfet
X$24 TS_CMP__t3 EN__t5 VIN__t135 VIN__t138 sky130_fd_pr__pfet_g5v0d10v5 L=0.5
+ W=2 AS=0.84 AD=0.84 PS=4.84 PD=4.84
* device instance $25 r0 *1 2251.63,20.15 pfet
X$25 EA_TAIL__t0 BIASP__t2 VIN__t8 VIN__t7 sky130_fd_pr__pfet_g5v0d10v5 L=2
+ W=40 AS=16.8 AD=16.8 PS=80.84 PD=80.84
* device instance $26 r0 *1 2256.77,5.15 pfet
X$26 EA_D1__t1 FB__t1 EA_TAIL__t1 VIN__t9 sky130_fd_pr__pfet_g5v0d10v5 L=2 W=10
+ AS=4.2 AD=4.2 PS=20.84 PD=20.84
* device instance $27 r0 *1 2261.91,5.15 pfet
X$27 EA_D2__t1 VREF__t0 EA_TAIL__t3 VIN__t133 sky130_fd_pr__pfet_g5v0d10v5 L=2
+ W=10 AS=4.2 AD=4.2 PS=20.84 PD=20.84
* device instance $28 r0 *1 2268.05,10.15 pfet
X$28 PB__t1 PB__t2 VIN__t11 VIN__t10 sky130_fd_pr__pfet_g5v0d10v5 L=4 W=20
+ AS=8.4 AD=8.4 PS=40.84 PD=40.84
* device instance $29 r0 *1 2275.19,10.15 pfet
X$29 EA_OUT__t56 PB__t3 VIN__t128 VIN__t129 sky130_fd_pr__pfet_g5v0d10v5 L=4
+ W=20 AS=8.4 AD=8.4 PS=40.84 PD=40.84
* device instance $30 r0 *1 2281.33,5.15 pfet
X$30 EA_D2__t0 SS__t2 EA_TAIL__t2 VIN__t132 sky130_fd_pr__pfet_g5v0d10v5 L=2
+ W=10 AS=4.2 AD=4.2 PS=20.84 PD=20.84
* device instance $31 r0 *1 2285.72,0.57 pfet
X$31 CL_SNS__t3 EA_OUT__t3 VIN__t13 VIN__t12 sky130_fd_pr__pfet_g5v0d10v5 L=0.5
+ W=0.84 AS=0.3528 AD=0.3528 PS=2.52 PD=2.52
* device instance $32 r0 *1 2289.61,5.15 pfet
X$32 CL_CMP__t3 BIASP__t7 VIN__t143 VIN__t144 sky130_fd_pr__pfet_g5v0d10v5 L=1
+ W=10 AS=4.2 AD=4.2 PS=20.84 PD=20.84
* device instance $33 r0 *1 2293.5,10.15 pfet
X$33 EA_OUT__t4 CL_CMP__t1 VIN__t15 VIN__t14 sky130_fd_pr__pfet_g5v0d10v5 L=0.5
+ W=20 AS=8.4 AD=8.4 PS=40.84 PD=40.84
* device instance $34 r0 *1 2297.14,1.15 pfet
X$34 ENB__t2 EN__t6 VIN__t136 VIN__t140 sky130_fd_pr__pfet_g5v0d10v5 L=0.5 W=2
+ AS=0.84 AD=0.84 PS=4.84 PD=4.84
* device instance $35 r0 *1 2304.53,0.65 pfet
X$35 SS__t1 BIASP__t3 VIN__t17 VIN__t16 sky130_fd_pr__pfet_g5v0d10v5 L=8 W=1
+ AS=0.42 AD=0.42 PS=2.84 PD=2.84
* device instance $36 r0 *1 2312.17,0.775 pfet
X$36 TS_SNS__t1 BIASP__t4 VIN__t19 VIN__t18 sky130_fd_pr__pfet_g5v0d10v5 L=1
+ W=1.25 AS=0.525 AD=0.525 PS=3.34 PD=3.34
* device instance $37 r0 *1 2316.31,3.65 pfet
X$37 TS_REF__t2 BIASP__t5 VIN__t21 VIN__t20 sky130_fd_pr__pfet_g5v0d10v5 L=1
+ W=7 AS=2.94 AD=2.94 PS=14.84 PD=14.84
* device instance $38 r0 *1 2320.95,5.15 pfet
X$38 TC_D1__t1 TC_D1__t2 VIN__t126 VIN__t130 sky130_fd_pr__pfet_g5v0d10v5 L=2
+ W=10 AS=4.2 AD=4.2 PS=20.84 PD=20.84
* device instance $39 r0 *1 2326.09,5.15 pfet
X$39 TS_CMP__t1 TC_D1__t3 VIN__t127 VIN__t131 sky130_fd_pr__pfet_g5v0d10v5 L=2
+ W=10 AS=4.2 AD=4.2 PS=20.84 PD=20.84
* device instance $40 r0 *1 2330.48,10.15 pfet
X$40 EA_OUT__t55 TS_CMP__t0 VIN__t124 VIN__t125 sky130_fd_pr__pfet_g5v0d10v5
+ L=0.5 W=20 AS=8.4 AD=8.4 PS=40.84 PD=40.84
* device instance $41 r0 *1 2334.87,2.4 pfet
X$41 TS_HYS__t0 BIASP__t6 VIN__t23 VIN__t22 sky130_fd_pr__pfet_g5v0d10v5 L=2
+ W=4.5 AS=1.89 AD=1.89 PS=9.84 PD=9.84
* device instance $42 r0 *1 2339.26,1.15 pfet
X$42 TS_REF__t3 TS_CMP__t2 TS_HYS__t1 VIN__t139 sky130_fd_pr__pfet_g5v0d10v5
+ L=0.5 W=2 AS=0.84 AD=0.84 PS=4.84 PD=4.84
* device instance $43 r0 *1 2342.9,50.15 pfet
X$43 VOUT__t1 EA_OUT__t5 VIN__t25 VIN__t24 sky130_fd_pr__pfet_g5v0d10v5 L=0.5
+ W=100 AS=42 AD=42 PS=200.84 PD=200.84
* device instance $44 r0 *1 2344.64,50.15 pfet
X$44 VOUT__t24 EA_OUT__t28 VIN__t48 VIN__t97 sky130_fd_pr__pfet_g5v0d10v5 L=0.5
+ W=100 AS=42 AD=42 PS=200.84 PD=200.84
* device instance $45 r0 *1 2346.38,50.15 pfet
X$45 VOUT__t23 EA_OUT__t27 VIN__t47 VIN__t96 sky130_fd_pr__pfet_g5v0d10v5 L=0.5
+ W=100 AS=42 AD=42 PS=200.84 PD=200.84
* device instance $46 r0 *1 2348.12,50.15 pfet
X$46 VOUT__t22 EA_OUT__t26 VIN__t46 VIN__t95 sky130_fd_pr__pfet_g5v0d10v5 L=0.5
+ W=100 AS=42 AD=42 PS=200.84 PD=200.84
* device instance $47 r0 *1 2349.86,50.15 pfet
X$47 VOUT__t21 EA_OUT__t25 VIN__t45 VIN__t94 sky130_fd_pr__pfet_g5v0d10v5 L=0.5
+ W=100 AS=42 AD=42 PS=200.84 PD=200.84
* device instance $48 r0 *1 2351.6,50.15 pfet
X$48 VOUT__t20 EA_OUT__t24 VIN__t44 VIN__t93 sky130_fd_pr__pfet_g5v0d10v5 L=0.5
+ W=100 AS=42 AD=42 PS=200.84 PD=200.84
* device instance $49 r0 *1 2353.34,50.15 pfet
X$49 VOUT__t26 EA_OUT__t30 VIN__t50 VIN__t99 sky130_fd_pr__pfet_g5v0d10v5 L=0.5
+ W=100 AS=42 AD=42 PS=200.84 PD=200.84
* device instance $50 r0 *1 2355.08,50.15 pfet
X$50 VOUT__t19 EA_OUT__t23 VIN__t43 VIN__t92 sky130_fd_pr__pfet_g5v0d10v5 L=0.5
+ W=100 AS=42 AD=42 PS=200.84 PD=200.84
* device instance $51 r0 *1 2356.82,50.15 pfet
X$51 VOUT__t18 EA_OUT__t22 VIN__t42 VIN__t91 sky130_fd_pr__pfet_g5v0d10v5 L=0.5
+ W=100 AS=42 AD=42 PS=200.84 PD=200.84
* device instance $52 r0 *1 2358.56,50.15 pfet
X$52 VOUT__t17 EA_OUT__t21 VIN__t41 VIN__t90 sky130_fd_pr__pfet_g5v0d10v5 L=0.5
+ W=100 AS=42 AD=42 PS=200.84 PD=200.84
* device instance $53 r0 *1 2360.3,50.15 pfet
X$53 VOUT__t16 EA_OUT__t20 VIN__t40 VIN__t89 sky130_fd_pr__pfet_g5v0d10v5 L=0.5
+ W=100 AS=42 AD=42 PS=200.84 PD=200.84
* device instance $54 r0 *1 2362.04,50.15 pfet
X$54 VOUT__t15 EA_OUT__t19 VIN__t39 VIN__t88 sky130_fd_pr__pfet_g5v0d10v5 L=0.5
+ W=100 AS=42 AD=42 PS=200.84 PD=200.84
* device instance $55 r0 *1 2363.78,50.15 pfet
X$55 VOUT__t14 EA_OUT__t18 VIN__t38 VIN__t87 sky130_fd_pr__pfet_g5v0d10v5 L=0.5
+ W=100 AS=42 AD=42 PS=200.84 PD=200.84
* device instance $56 r0 *1 2365.52,50.15 pfet
X$56 VOUT__t2 EA_OUT__t6 VIN__t26 VIN__t75 sky130_fd_pr__pfet_g5v0d10v5 L=0.5
+ W=100 AS=42 AD=42 PS=200.84 PD=200.84
* device instance $57 r0 *1 2367.26,50.15 pfet
X$57 VOUT__t13 EA_OUT__t17 VIN__t37 VIN__t86 sky130_fd_pr__pfet_g5v0d10v5 L=0.5
+ W=100 AS=42 AD=42 PS=200.84 PD=200.84
* device instance $58 r0 *1 2369,50.15 pfet
X$58 VOUT__t3 EA_OUT__t7 VIN__t27 VIN__t76 sky130_fd_pr__pfet_g5v0d10v5 L=0.5
+ W=100 AS=42 AD=42 PS=200.84 PD=200.84
* device instance $59 r0 *1 2370.74,50.15 pfet
X$59 VOUT__t4 EA_OUT__t8 VIN__t28 VIN__t77 sky130_fd_pr__pfet_g5v0d10v5 L=0.5
+ W=100 AS=42 AD=42 PS=200.84 PD=200.84
* device instance $60 r0 *1 2372.48,50.15 pfet
X$60 VOUT__t5 EA_OUT__t9 VIN__t29 VIN__t78 sky130_fd_pr__pfet_g5v0d10v5 L=0.5
+ W=100 AS=42 AD=42 PS=200.84 PD=200.84
* device instance $61 r0 *1 2374.22,50.15 pfet
X$61 VOUT__t6 EA_OUT__t10 VIN__t30 VIN__t79 sky130_fd_pr__pfet_g5v0d10v5 L=0.5
+ W=100 AS=42 AD=42 PS=200.84 PD=200.84
* device instance $62 r0 *1 2375.96,50.15 pfet
X$62 VOUT__t7 EA_OUT__t11 VIN__t31 VIN__t80 sky130_fd_pr__pfet_g5v0d10v5 L=0.5
+ W=100 AS=42 AD=42 PS=200.84 PD=200.84
* device instance $63 r0 *1 2377.7,50.15 pfet
X$63 VOUT__t8 EA_OUT__t12 VIN__t32 VIN__t81 sky130_fd_pr__pfet_g5v0d10v5 L=0.5
+ W=100 AS=42 AD=42 PS=200.84 PD=200.84
* device instance $64 r0 *1 2379.44,50.15 pfet
X$64 VOUT__t9 EA_OUT__t13 VIN__t33 VIN__t82 sky130_fd_pr__pfet_g5v0d10v5 L=0.5
+ W=100 AS=42 AD=42 PS=200.84 PD=200.84
* device instance $65 r0 *1 2381.18,50.15 pfet
X$65 VOUT__t10 EA_OUT__t14 VIN__t34 VIN__t83 sky130_fd_pr__pfet_g5v0d10v5 L=0.5
+ W=100 AS=42 AD=42 PS=200.84 PD=200.84
* device instance $66 r0 *1 2382.92,50.15 pfet
X$66 VOUT__t11 EA_OUT__t15 VIN__t35 VIN__t84 sky130_fd_pr__pfet_g5v0d10v5 L=0.5
+ W=100 AS=42 AD=42 PS=200.84 PD=200.84
* device instance $67 r0 *1 2384.66,50.15 pfet
X$67 VOUT__t25 EA_OUT__t29 VIN__t49 VIN__t98 sky130_fd_pr__pfet_g5v0d10v5 L=0.5
+ W=100 AS=42 AD=42 PS=200.84 PD=200.84
* device instance $68 r0 *1 2386.4,50.15 pfet
X$68 VOUT__t12 EA_OUT__t16 VIN__t36 VIN__t85 sky130_fd_pr__pfet_g5v0d10v5 L=0.5
+ W=100 AS=42 AD=42 PS=200.84 PD=200.84
* device instance $69 r0 *1 2388.14,50.15 pfet
X$69 VOUT__t39 EA_OUT__t43 VIN__t63 VIN__t112 sky130_fd_pr__pfet_g5v0d10v5
+ L=0.5 W=100 AS=42 AD=42 PS=200.84 PD=200.84
* device instance $70 r0 *1 2389.88,50.15 pfet
X$70 VOUT__t40 EA_OUT__t44 VIN__t64 VIN__t113 sky130_fd_pr__pfet_g5v0d10v5
+ L=0.5 W=100 AS=42 AD=42 PS=200.84 PD=200.84
* device instance $71 r0 *1 2391.62,50.15 pfet
X$71 VOUT__t41 EA_OUT__t45 VIN__t65 VIN__t114 sky130_fd_pr__pfet_g5v0d10v5
+ L=0.5 W=100 AS=42 AD=42 PS=200.84 PD=200.84
* device instance $72 r0 *1 2393.36,50.15 pfet
X$72 VOUT__t42 EA_OUT__t46 VIN__t66 VIN__t115 sky130_fd_pr__pfet_g5v0d10v5
+ L=0.5 W=100 AS=42 AD=42 PS=200.84 PD=200.84
* device instance $73 r0 *1 2395.1,50.15 pfet
X$73 VOUT__t43 EA_OUT__t47 VIN__t67 VIN__t116 sky130_fd_pr__pfet_g5v0d10v5
+ L=0.5 W=100 AS=42 AD=42 PS=200.84 PD=200.84
* device instance $74 r0 *1 2396.84,50.15 pfet
X$74 VOUT__t44 EA_OUT__t48 VIN__t68 VIN__t117 sky130_fd_pr__pfet_g5v0d10v5
+ L=0.5 W=100 AS=42 AD=42 PS=200.84 PD=200.84
* device instance $75 r0 *1 2398.58,50.15 pfet
X$75 VOUT__t45 EA_OUT__t49 VIN__t69 VIN__t118 sky130_fd_pr__pfet_g5v0d10v5
+ L=0.5 W=100 AS=42 AD=42 PS=200.84 PD=200.84
* device instance $76 r0 *1 2400.32,50.15 pfet
X$76 VOUT__t46 EA_OUT__t50 VIN__t70 VIN__t119 sky130_fd_pr__pfet_g5v0d10v5
+ L=0.5 W=100 AS=42 AD=42 PS=200.84 PD=200.84
* device instance $77 r0 *1 2402.06,50.15 pfet
X$77 VOUT__t47 EA_OUT__t51 VIN__t71 VIN__t120 sky130_fd_pr__pfet_g5v0d10v5
+ L=0.5 W=100 AS=42 AD=42 PS=200.84 PD=200.84
* device instance $78 r0 *1 2403.8,50.15 pfet
X$78 VOUT__t48 EA_OUT__t52 VIN__t72 VIN__t121 sky130_fd_pr__pfet_g5v0d10v5
+ L=0.5 W=100 AS=42 AD=42 PS=200.84 PD=200.84
* device instance $79 r0 *1 2405.54,50.15 pfet
X$79 VOUT__t49 EA_OUT__t53 VIN__t73 VIN__t122 sky130_fd_pr__pfet_g5v0d10v5
+ L=0.5 W=100 AS=42 AD=42 PS=200.84 PD=200.84
* device instance $80 r0 *1 2407.28,50.15 pfet
X$80 VOUT__t50 EA_OUT__t54 VIN__t74 VIN__t123 sky130_fd_pr__pfet_g5v0d10v5
+ L=0.5 W=100 AS=42 AD=42 PS=200.84 PD=200.84
* device instance $81 r0 *1 2409.02,50.15 pfet
X$81 VOUT__t38 EA_OUT__t42 VIN__t62 VIN__t111 sky130_fd_pr__pfet_g5v0d10v5
+ L=0.5 W=100 AS=42 AD=42 PS=200.84 PD=200.84
* device instance $82 r0 *1 2410.76,50.15 pfet
X$82 VOUT__t37 EA_OUT__t41 VIN__t61 VIN__t110 sky130_fd_pr__pfet_g5v0d10v5
+ L=0.5 W=100 AS=42 AD=42 PS=200.84 PD=200.84
* device instance $83 r0 *1 2412.5,50.15 pfet
X$83 VOUT__t36 EA_OUT__t40 VIN__t60 VIN__t109 sky130_fd_pr__pfet_g5v0d10v5
+ L=0.5 W=100 AS=42 AD=42 PS=200.84 PD=200.84
* device instance $84 r0 *1 2414.24,50.15 pfet
X$84 VOUT__t35 EA_OUT__t39 VIN__t59 VIN__t108 sky130_fd_pr__pfet_g5v0d10v5
+ L=0.5 W=100 AS=42 AD=42 PS=200.84 PD=200.84
* device instance $85 r0 *1 2415.98,50.15 pfet
X$85 VOUT__t34 EA_OUT__t38 VIN__t58 VIN__t107 sky130_fd_pr__pfet_g5v0d10v5
+ L=0.5 W=100 AS=42 AD=42 PS=200.84 PD=200.84
* device instance $86 r0 *1 2417.72,50.15 pfet
X$86 VOUT__t33 EA_OUT__t37 VIN__t57 VIN__t106 sky130_fd_pr__pfet_g5v0d10v5
+ L=0.5 W=100 AS=42 AD=42 PS=200.84 PD=200.84
* device instance $87 r0 *1 2419.46,50.15 pfet
X$87 VOUT__t32 EA_OUT__t36 VIN__t56 VIN__t105 sky130_fd_pr__pfet_g5v0d10v5
+ L=0.5 W=100 AS=42 AD=42 PS=200.84 PD=200.84
* device instance $88 r0 *1 2421.2,50.15 pfet
X$88 VOUT__t31 EA_OUT__t35 VIN__t55 VIN__t104 sky130_fd_pr__pfet_g5v0d10v5
+ L=0.5 W=100 AS=42 AD=42 PS=200.84 PD=200.84
* device instance $89 r0 *1 2422.94,50.15 pfet
X$89 VOUT__t30 EA_OUT__t34 VIN__t54 VIN__t103 sky130_fd_pr__pfet_g5v0d10v5
+ L=0.5 W=100 AS=42 AD=42 PS=200.84 PD=200.84
* device instance $90 r0 *1 2424.68,50.15 pfet
X$90 VOUT__t29 EA_OUT__t33 VIN__t53 VIN__t102 sky130_fd_pr__pfet_g5v0d10v5
+ L=0.5 W=100 AS=42 AD=42 PS=200.84 PD=200.84
* device instance $91 r0 *1 2426.42,50.15 pfet
X$91 VOUT__t28 EA_OUT__t32 VIN__t52 VIN__t101 sky130_fd_pr__pfet_g5v0d10v5
+ L=0.5 W=100 AS=42 AD=42 PS=200.84 PD=200.84
* device instance $92 r0 *1 2428.16,50.15 pfet
X$92 VOUT__t27 EA_OUT__t31 VIN__t51 VIN__t100 sky130_fd_pr__pfet_g5v0d10v5
+ L=0.5 W=100 AS=42 AD=42 PS=200.84 PD=200.84
* device instance $93 r0 *1 750.42,0.21 res_high_po
X$93 VIN__t0 NB__t0 0__t0 sky130_fd_pr__res_high_po l=1500 w=0.42
* device instance $94 r0 *1 1593.26,0.21 res_xhigh_po
X$94 VOUT__t0 FB__t0 0__t1 sky130_fd_pr__res_xhigh_po l=180 w=0.42
* device instance $95 r0 *1 1776.1,0.21 res_xhigh_po
X$95 FB__t2 N_FBB__t0 0__t2 sky130_fd_pr__res_xhigh_po l=180 w=0.42
* device instance $96 r0 *1 1958.94,0.21 res_xhigh_po
X$96 N_FBB__t1 0__t27 0__t3 sky130_fd_pr__res_xhigh_po l=180 w=0.42
* device instance $97 r0 *1 2077.78,0.21 res_xhigh_po
X$97 EA_CZ__t0 EA_OUT__t0 0__t4 sky130_fd_pr__res_xhigh_po l=52 w=0.42
* device instance 0_t0 r0 *1 0,0
R0_t0 0__t0 0 1027.37615389
* device instance 0_t1 r0 *1 0,0
R0_t1 0__t1 0 367.284989142
* device instance 0_t2 r0 *1 0,0
R0_t2 0__t2 0 224.100812924
* device instance 0_t3 r0 *1 0,0
R0_t3 0__t3 0 80.9688088
* device instance 0_t4 r0 *1 0,0
R0_t4 0__t4 0 12.8859371084
* device instance 0_t5 r0 *1 0,0
R0_t5 0__t5 0 106.22979477
* device instance 0_t6 r0 *1 0,0
R0_t6 0__t6 0 88.7616528664
* device instance 0_t7 r0 *1 0,0
R0_t7 0__t7 0 109.853282458
* device instance 0_t8 r0 *1 0,0
R0_t8 0__t8 0 85.7078654626
* device instance 0_t9 r0 *1 0,0
R0_t9 0__t9 0 91.5946877193
* device instance 0_t10 r0 *1 0,0
R0_t10 0__t10 0 47.9084364378
* device instance 0_t11 r0 *1 0,0
R0_t11 0__t11 0 53.9937214726
* device instance 0_t12 r0 *1 0,0
R0_t12 0__t12 0 50.8851828947
* device instance 0_t13 r0 *1 0,0
R0_t13 0__t13 0 56.9783560889
* device instance 0_t14 r0 *1 0,0
R0_t14 0__t14 0 61.1997265615
* device instance 0_t15 r0 *1 0,0
R0_t15 0__t15 0 66.7916791145
* device instance 0_t16 r0 *1 0,0
R0_t16 0__t16 0 72.3836381732
* device instance 0_t17 r0 *1 0,0
R0_t17 0__t17 0 77.9756023378
* device instance 0_t18 r0 *1 0,0
R0_t18 0__t18 0 113.42277285
* device instance 0_t19 r0 *1 0,0
R0_t19 0__t19 0 117.448373149
* device instance 0_t20 r0 *1 0,0
R0_t20 0__t20 0 82.4740140059
* device instance 0_t21 r0 *1 0,0
R0_t21 0__t21 0 99.5320545699
* device instance 0_t22 r0 *1 0,0
R0_t22 0__t22 0 104.922868829
* device instance 0_t23 r0 *1 0,0
R0_t23 0__t23 0 50.8851828947
* device instance 0_t24 r0 *1 0,0
R0_t24 0__t24 0 88.7616528664
* device instance 0_t25 r0 *1 0,0
R0_t25 0__t25 0 91.5946877193
* device instance 0_t26 r0 *1 0,0
R0_t26 0__t26 0 56.9783560889
* device instance 0_t27 r0 *1 0,0
R0_t27 0__t27 0 80.9688088
* device instance 0 r0 *1 0,0
C0 0 vsubs 1.8036468e-14
* device instance AMP_ENN_t0 r0 *1 0,0
RAMP_ENN_t0 AMP_ENN__t0 AMP_ENN 1403.01066047
* device instance AMP_ENN_t1 r0 *1 0,0
RAMP_ENN_t1 AMP_ENN__t1 AMP_ENN 125.04181058
* device instance AMP_ENN_t2 r0 *1 0,0
RAMP_ENN_t2 AMP_ENN__t2 AMP_ENN 431.252390992
* device instance AMP_ENN_t3 r0 *1 0,0
RAMP_ENN_t3 AMP_ENN__t3 AMP_ENN 1658.41410897
* device instance AMP_ENN_t4 r0 *1 0,0
RAMP_ENN_t4 AMP_ENN__t4 AMP_ENN 1892.54964896
* device instance AMP_ENN_t5 r0 *1 0,0
RAMP_ENN_t5 AMP_ENN__t5 AMP_ENN 2130.33816504
* device instance AMP_ENN_t6 r0 *1 0,0
RAMP_ENN_t6 AMP_ENN__t6 AMP_ENN 1031.34513199
* device instance AMP_ENN_t7 r0 *1 0,0
RAMP_ENN_t7 AMP_ENN__t7 AMP_ENN 662.50521416
* device instance AMP_ENN_t8 r0 *1 0,0
RAMP_ENN_t8 AMP_ENN__t8 AMP_ENN 306.855089427
* device instance AMP_ENN_t9 r0 *1 0,0
RAMP_ENN_t9 AMP_ENN__t9 AMP_ENN 1684.31647941
* device instance AMP_ENN r0 *1 0,0
CAMP_ENN AMP_ENN vsubs 3.1565069e-14
* device instance BIASP_t0 r0 *1 0,0
RBIASP_t0 BIASP__t0 BIASP 374.23241754
* device instance BIASP_t1 r0 *1 0,0
RBIASP_t1 BIASP__t1 BIASP 374.23241754
* device instance BIASP_t2 r0 *1 0,0
RBIASP_t2 BIASP__t2 BIASP 206.905659164
* device instance BIASP_t3 r0 *1 0,0
RBIASP_t3 BIASP__t3 BIASP 455.792994915
* device instance BIASP_t4 r0 *1 0,0
RBIASP_t4 BIASP__t4 BIASP 538.752485869
* device instance BIASP_t5 r0 *1 0,0
RBIASP_t5 BIASP__t5 BIASP 582.164837259
* device instance BIASP_t6 r0 *1 0,0
RBIASP_t6 BIASP__t6 BIASP 785.273195859
* device instance BIASP_t7 r0 *1 0,0
RBIASP_t7 BIASP__t7 BIASP 290.259777313
* device instance BIASP_t8 r0 *1 0,0
RBIASP_t8 BIASP__t8 BIASP 331.732566581
* device instance BIASP_t9 r0 *1 0,0
RBIASP_t9 BIASP__t9 BIASP 1442.43164796
* device instance BIASP r0 *1 0,0
CBIASP BIASP vsubs 4.0608192e-14
* device instance BIAS_ENN_t0 r0 *1 0,0
RBIAS_ENN_t0 BIAS_ENN__t0 BIAS_ENN 902.588576798
* device instance BIAS_ENN_t1 r0 *1 0,0
RBIAS_ENN_t1 BIAS_ENN__t1 BIAS_ENN 449.442746404
* device instance BIAS_ENN_t2 r0 *1 0,0
RBIAS_ENN_t2 BIAS_ENN__t2 BIAS_ENN 902.588576798
* device instance BIAS_ENN r0 *1 0,0
CBIAS_ENN BIAS_ENN vsubs 5.108368e-15
* device instance CL_CMP_t0 r0 *1 0,0
RCL_CMP_t0 CL_CMP__t0 CL_CMP 1718.9086012
* device instance CL_CMP_t1 r0 *1 0,0
RCL_CMP_t1 CL_CMP__t1 CL_CMP 975.416798905
* device instance CL_CMP_t2 r0 *1 0,0
RCL_CMP_t2 CL_CMP__t2 CL_CMP 148.877782753
* device instance CL_CMP_t3 r0 *1 0,0
RCL_CMP_t3 CL_CMP__t3 CL_CMP 881.593617141
* device instance CL_CMP r0 *1 0,0
CCL_CMP CL_CMP vsubs 2.001752e-14
* device instance CL_SNS_t0 r0 *1 0,0
RCL_SNS_t0 CL_SNS__t0 CL_SNS 542.242570364
* device instance CL_SNS_t1 r0 *1 0,0
RCL_SNS_t1 CL_SNS__t1 CL_SNS 542.242570364
* device instance CL_SNS_t2 r0 *1 0,0
RCL_SNS_t2 CL_SNS__t2 CL_SNS 470.165610764
* device instance CL_SNS_t3 r0 *1 0,0
RCL_SNS_t3 CL_SNS__t3 CL_SNS 1537.83914851
* device instance CL_SNS r0 *1 0,0
CCL_SNS CL_SNS vsubs 2.0901374e-14
* device instance EA_CZ_t0 r0 *1 0,0
REA_CZ_t0 EA_CZ__t0 EA_CZ 604.9967
* device instance EA_CZ r0 *1 0,0
CEA_CZ EA_CZ vsubs 9.25245e-16
* device instance EA_D1_t0 r0 *1 0,0
REA_D1_t0 EA_D1__t0 EA_D1 501.623672623
* device instance EA_D1_t1 r0 *1 0,0
REA_D1_t1 EA_D1__t1 EA_D1 1388.9431
* device instance EA_D1_t2 r0 *1 0,0
REA_D1_t2 EA_D1__t2 EA_D1 385.695754755
* device instance EA_D1_t3 r0 *1 0,0
REA_D1_t3 EA_D1__t3 EA_D1 501.623672623
* device instance EA_D1 r0 *1 0,0
CEA_D1 EA_D1 vsubs 1.9785434e-14
* device instance EA_D2_t0 r0 *1 0,0
REA_D2_t0 EA_D2__t0 EA_D2 1132.88725941
* device instance EA_D2_t1 r0 *1 0,0
REA_D2_t1 EA_D2__t1 EA_D2 852.581090594
* device instance EA_D2_t2 r0 *1 0,0
REA_D2_t2 EA_D2__t2 EA_D2 696.175444599
* device instance EA_D2_t3 r0 *1 0,0
REA_D2_t3 EA_D2__t3 EA_D2 593.117460803
* device instance EA_D2_t4 r0 *1 0,0
REA_D2_t4 EA_D2__t4 EA_D2 696.175444599
* device instance EA_D2 r0 *1 0,0
CEA_D2 EA_D2 vsubs 2.3156611e-14
* device instance EA_OUT_t0 r0 *1 0,0
REA_OUT_t0 EA_OUT__t0 EA_OUT 3418.81383953
* device instance EA_OUT_t1 r0 *1 0,0
REA_OUT_t1 EA_OUT__t1 EA_OUT 2606.34576783
* device instance EA_OUT_t2 r0 *1 0,0
REA_OUT_t2 EA_OUT__t2 EA_OUT 1595.62933505
* device instance EA_OUT_t3 r0 *1 0,0
REA_OUT_t3 EA_OUT__t3 EA_OUT 1081.12332472
* device instance EA_OUT_t4 r0 *1 0,0
REA_OUT_t4 EA_OUT__t4 EA_OUT 949.472048759
* device instance EA_OUT_t5 r0 *1 0,0
REA_OUT_t5 EA_OUT__t5 EA_OUT 289.349501671
* device instance EA_OUT_t6 r0 *1 0,0
REA_OUT_t6 EA_OUT__t6 EA_OUT 65.9589444402
* device instance EA_OUT_t7 r0 *1 0,0
REA_OUT_t7 EA_OUT__t7 EA_OUT 67.3164412376
* device instance EA_OUT_t8 r0 *1 0,0
REA_OUT_t8 EA_OUT__t8 EA_OUT 76.558291435
* device instance EA_OUT_t9 r0 *1 0,0
REA_OUT_t9 EA_OUT__t9 EA_OUT 89.5375874254
* device instance EA_OUT_t10 r0 *1 0,0
REA_OUT_t10 EA_OUT__t10 EA_OUT 104.875764524
* device instance EA_OUT_t11 r0 *1 0,0
REA_OUT_t11 EA_OUT__t11 EA_OUT 121.684063274
* device instance EA_OUT_t12 r0 *1 0,0
REA_OUT_t12 EA_OUT__t12 EA_OUT 139.43183056
* device instance EA_OUT_t13 r0 *1 0,0
REA_OUT_t13 EA_OUT__t13 EA_OUT 157.802402832
* device instance EA_OUT_t14 r0 *1 0,0
REA_OUT_t14 EA_OUT__t14 EA_OUT 176.601529308
* device instance EA_OUT_t15 r0 *1 0,0
REA_OUT_t15 EA_OUT__t15 EA_OUT 195.705750595
* device instance EA_OUT_t16 r0 *1 0,0
REA_OUT_t16 EA_OUT__t16 EA_OUT 234.530251107
* device instance EA_OUT_t17 r0 *1 0,0
REA_OUT_t17 EA_OUT__t17 EA_OUT 63.4663169114
* device instance EA_OUT_t18 r0 *1 0,0
REA_OUT_t18 EA_OUT__t18 EA_OUT 74.1574687336
* device instance EA_OUT_t19 r0 *1 0,0
REA_OUT_t19 EA_OUT__t19 EA_OUT 86.4535530459
* device instance EA_OUT_t20 r0 *1 0,0
REA_OUT_t20 EA_OUT__t20 EA_OUT 101.366870069
* device instance EA_OUT_t21 r0 *1 0,0
REA_OUT_t21 EA_OUT__t21 EA_OUT 117.908467502
* device instance EA_OUT_t22 r0 *1 0,0
REA_OUT_t22 EA_OUT__t22 EA_OUT 135.483245893
* device instance EA_OUT_t23 r0 *1 0,0
REA_OUT_t23 EA_OUT__t23 EA_OUT 153.737282319
* device instance EA_OUT_t24 r0 *1 0,0
REA_OUT_t24 EA_OUT__t24 EA_OUT 191.500529067
* device instance EA_OUT_t25 r0 *1 0,0
REA_OUT_t25 EA_OUT__t25 EA_OUT 210.784988161
* device instance EA_OUT_t26 r0 *1 0,0
REA_OUT_t26 EA_OUT__t26 EA_OUT 230.248363041
* device instance EA_OUT_t27 r0 *1 0,0
REA_OUT_t27 EA_OUT__t27 EA_OUT 249.848844264
* device instance EA_OUT_t28 r0 *1 0,0
REA_OUT_t28 EA_OUT__t28 EA_OUT 269.556524916
* device instance EA_OUT_t29 r0 *1 0,0
REA_OUT_t29 EA_OUT__t29 EA_OUT 215.033765549
* device instance EA_OUT_t30 r0 *1 0,0
REA_OUT_t30 EA_OUT__t30 EA_OUT 172.455016975
* device instance EA_OUT_t31 r0 *1 0,0
REA_OUT_t31 EA_OUT__t31 EA_OUT 716.382672646
* device instance EA_OUT_t32 r0 *1 0,0
REA_OUT_t32 EA_OUT__t32 EA_OUT 696.140706293
* device instance EA_OUT_t33 r0 *1 0,0
REA_OUT_t33 EA_OUT__t33 EA_OUT 675.903669984
* device instance EA_OUT_t34 r0 *1 0,0
REA_OUT_t34 EA_OUT__t34 EA_OUT 655.672020208
* device instance EA_OUT_t35 r0 *1 0,0
REA_OUT_t35 EA_OUT__t35 EA_OUT 635.446271465
* device instance EA_OUT_t36 r0 *1 0,0
REA_OUT_t36 EA_OUT__t36 EA_OUT 615.227005748
* device instance EA_OUT_t37 r0 *1 0,0
REA_OUT_t37 EA_OUT__t37 EA_OUT 595.014883959
* device instance EA_OUT_t38 r0 *1 0,0
REA_OUT_t38 EA_OUT__t38 EA_OUT 574.810659705
* device instance EA_OUT_t39 r0 *1 0,0
REA_OUT_t39 EA_OUT__t39 EA_OUT 554.615196093
* device instance EA_OUT_t40 r0 *1 0,0
REA_OUT_t40 EA_OUT__t40 EA_OUT 534.429486286
* device instance EA_OUT_t41 r0 *1 0,0
REA_OUT_t41 EA_OUT__t41 EA_OUT 514.254678865
* device instance EA_OUT_t42 r0 *1 0,0
REA_OUT_t42 EA_OUT__t42 EA_OUT 494.092109333
* device instance EA_OUT_t43 r0 *1 0,0
REA_OUT_t43 EA_OUT__t43 EA_OUT 254.156439798
* device instance EA_OUT_t44 r0 *1 0,0
REA_OUT_t44 EA_OUT__t44 EA_OUT 273.884449987
* device instance EA_OUT_t45 r0 *1 0,0
REA_OUT_t45 EA_OUT__t45 EA_OUT 293.693763718
* device instance EA_OUT_t46 r0 *1 0,0
REA_OUT_t46 EA_OUT__t46 EA_OUT 313.568972631
* device instance EA_OUT_t47 r0 *1 0,0
REA_OUT_t47 EA_OUT__t47 EA_OUT 333.49829564
* device instance EA_OUT_t48 r0 *1 0,0
REA_OUT_t48 EA_OUT__t48 EA_OUT 353.472579758
* device instance EA_OUT_t49 r0 *1 0,0
REA_OUT_t49 EA_OUT__t49 EA_OUT 373.484611376
* device instance EA_OUT_t50 r0 *1 0,0
REA_OUT_t50 EA_OUT__t50 EA_OUT 393.528631838
* device instance EA_OUT_t51 r0 *1 0,0
REA_OUT_t51 EA_OUT__t51 EA_OUT 413.599990409
* device instance EA_OUT_t52 r0 *1 0,0
REA_OUT_t52 EA_OUT__t52 EA_OUT 433.694891489
* device instance EA_OUT_t53 r0 *1 0,0
REA_OUT_t53 EA_OUT__t53 EA_OUT 453.810207674
* device instance EA_OUT_t54 r0 *1 0,0
REA_OUT_t54 EA_OUT__t54 EA_OUT 473.94333957
* device instance EA_OUT_t55 r0 *1 0,0
REA_OUT_t55 EA_OUT__t55 EA_OUT 587.968129327
* device instance EA_OUT_t56 r0 *1 0,0
REA_OUT_t56 EA_OUT__t56 EA_OUT 1146.65082544
* device instance EA_OUT r0 *1 0,0
CEA_OUT EA_OUT vsubs 5.1784067e-13
* device instance EA_TAIL_t0 r0 *1 0,0
REA_TAIL_t0 EA_TAIL__t0 EA_TAIL 2559.65490228
* device instance EA_TAIL_t1 r0 *1 0,0
REA_TAIL_t1 EA_TAIL__t1 EA_TAIL 1155.95461089
* device instance EA_TAIL_t2 r0 *1 0,0
REA_TAIL_t2 EA_TAIL__t2 EA_TAIL 3020.24973621
* device instance EA_TAIL_t3 r0 *1 0,0
REA_TAIL_t3 EA_TAIL__t3 EA_TAIL 623.567350621
* device instance EA_TAIL r0 *1 0,0
CEA_TAIL EA_TAIL vsubs 1.7485073e-14
* device instance EN_t0 r0 *1 0,0
REN_t0 EN__t0 EN 747.833455556
* device instance EN_t1 r0 *1 0,0
REN_t1 EN__t1 EN 337.105306812
* device instance EN_t2 r0 *1 0,0
REN_t2 EN__t2 EN 152.323695511
* device instance EN_t3 r0 *1 0,0
REN_t3 EN__t3 EN 213.588019979
* device instance EN_t4 r0 *1 0,0
REN_t4 EN__t4 EN 244.52430861
* device instance EN_t5 r0 *1 0,0
REN_t5 EN__t5 EN 275.474967753
* device instance EN_t6 r0 *1 0,0
REN_t6 EN__t6 EN 700.213158122
* device instance EN_t7 r0 *1 0,0
REN_t7 EN__t7 EN 183.114044158
* device instance EN_t8 r0 *1 0,0
REN_t8 EN__t8 EN 681.599243499
* device instance EN r0 *1 0,0
CEN EN vsubs 3.2922011e-14
* device instance ENB_t0 r0 *1 0,0
RENB_t0 ENB__t0 ENB 694.468521841
* device instance ENB_t1 r0 *1 0,0
RENB_t1 ENB__t1 ENB 633.95985697
* device instance ENB_t2 r0 *1 0,0
RENB_t2 ENB__t2 ENB 1328.40312119
* device instance ENB r0 *1 0,0
CENB ENB vsubs 1.6342314e-14
* device instance FB_t0 r0 *1 0,0
RFB_t0 FB__t0 FB 638.516161383
* device instance FB_t1 r0 *1 0,0
RFB_t1 FB__t1 FB 863.227049269
* device instance FB_t2 r0 *1 0,0
RFB_t2 FB__t2 FB 224.720489348
* device instance FB r0 *1 0,0
CFB FB vsubs 5.4182145e-14
* device instance NB_t0 r0 *1 0,0
RNB_t0 NB__t0 NB 1089.44102968
* device instance NB_t1 r0 *1 0,0
RNB_t1 NB__t1 NB 251.151360512
* device instance NB_t2 r0 *1 0,0
RNB_t2 NB__t2 NB 251.151360512
* device instance NB_t3 r0 *1 0,0
RNB_t3 NB__t3 NB 328.392729412
* device instance NB_t4 r0 *1 0,0
RNB_t4 NB__t4 NB 258.748519886
* device instance NB r0 *1 0,0
CNB NB vsubs 6.7468138e-14
* device instance N_FBB_t0 r0 *1 0,0
RN_FBB_t0 N_FBB__t0 N_FBB 602.9329
* device instance N_FBB_t1 r0 *1 0,0
RN_FBB_t1 N_FBB__t1 N_FBB 602.9329
* device instance N_FBB r0 *1 0,0
CN_FBB N_FBB vsubs 1.735803e-15
* device instance PB_t0 r0 *1 0,0
RPB_t0 PB__t0 PB 163.556463696
* device instance PB_t1 r0 *1 0,0
RPB_t1 PB__t1 PB 621.432983422
* device instance PB_t2 r0 *1 0,0
RPB_t2 PB__t2 PB 621.432983422
* device instance PB_t3 r0 *1 0,0
RPB_t3 PB__t3 PB 793.917234391
* device instance PB_t4 r0 *1 0,0
RPB_t4 PB__t4 PB 1963.06473507
* device instance PB r0 *1 0,0
CPB PB vsubs 2.3838052e-14
* device instance SS_t0 r0 *1 0,0
RSS_t0 SS__t0 SS 1383.91788972
* device instance SS_t1 r0 *1 0,0
RSS_t1 SS__t1 SS 903.833718608
* device instance SS_t2 r0 *1 0,0
RSS_t2 SS__t2 SS 483.199491668
* device instance SS r0 *1 0,0
CSS SS vsubs 1.7871223e-14
* device instance TC_D1_t0 r0 *1 0,0
RTC_D1_t0 TC_D1__t0 TC_D1 1938.6835
* device instance TC_D1_t1 r0 *1 0,0
RTC_D1_t1 TC_D1__t1 TC_D1 607.933954346
* device instance TC_D1_t2 r0 *1 0,0
RTC_D1_t2 TC_D1__t2 TC_D1 607.933954346
* device instance TC_D1_t3 r0 *1 0,0
RTC_D1_t3 TC_D1__t3 TC_D1 722.815591307
* device instance TC_D1 r0 *1 0,0
CTC_D1 TC_D1 vsubs 2.2822198e-14
* device instance TC_TAIL_t0 r0 *1 0,0
RTC_TAIL_t0 TC_TAIL__t0 TC_TAIL 2026.19746047
* device instance TC_TAIL_t1 r0 *1 0,0
RTC_TAIL_t1 TC_TAIL__t1 TC_TAIL 539.706400544
* device instance TC_TAIL_t2 r0 *1 0,0
RTC_TAIL_t2 TC_TAIL__t2 TC_TAIL 1857.61373898
* device instance TC_TAIL r0 *1 0,0
CTC_TAIL TC_TAIL vsubs 8.321453e-15
* device instance TS_CMP_t0 r0 *1 0,0
RTS_CMP_t0 TS_CMP__t0 TS_CMP 888.86349559
* device instance TS_CMP_t1 r0 *1 0,0
RTS_CMP_t1 TS_CMP__t1 TS_CMP 782.18444578
* device instance TS_CMP_t2 r0 *1 0,0
RTS_CMP_t2 TS_CMP__t2 TS_CMP 1078.6370904
* device instance TS_CMP_t3 r0 *1 0,0
RTS_CMP_t3 TS_CMP__t3 TS_CMP 980.449338102
* device instance TS_CMP_t4 r0 *1 0,0
RTS_CMP_t4 TS_CMP__t4 TS_CMP 1760.61183012
* device instance TS_CMP r0 *1 0,0
CTS_CMP TS_CMP vsubs 2.6148826e-14
* device instance TS_HYS_t0 r0 *1 0,0
RTS_HYS_t0 TS_HYS__t0 TS_HYS 1698.04435
* device instance TS_HYS_t1 r0 *1 0,0
RTS_HYS_t1 TS_HYS__t1 TS_HYS 1698.04435
* device instance TS_HYS r0 *1 0,0
CTS_HYS TS_HYS vsubs 5.364224e-15
* device instance TS_MID_t0 r0 *1 0,0
RTS_MID_t0 TS_MID__t0 TS_MID 3497.6095
* device instance TS_MID_t1 r0 *1 0,0
RTS_MID_t1 TS_MID__t1 TS_MID 1748.80475
* device instance TS_MID_t2 r0 *1 0,0
RTS_MID_t2 TS_MID__t2 TS_MID 1748.80475
* device instance TS_MID r0 *1 0,0
CTS_MID TS_MID vsubs 2.8489838e-14
* device instance TS_REF_t0 r0 *1 0,0
RTS_REF_t0 TS_REF__t0 TS_REF 895.835091273
* device instance TS_REF_t1 r0 *1 0,0
RTS_REF_t1 TS_REF__t1 TS_REF 895.835091273
* device instance TS_REF_t2 r0 *1 0,0
RTS_REF_t2 TS_REF__t2 TS_REF 1038.64441036
* device instance TS_REF_t3 r0 *1 0,0
RTS_REF_t3 TS_REF__t3 TS_REF 1412.69351219
* device instance TS_REF_t4 r0 *1 0,0
RTS_REF_t4 TS_REF__t4 TS_REF 662.046194909
* device instance TS_REF r0 *1 0,0
CTS_REF TS_REF vsubs 2.437501e-14
* device instance TS_SNS_t0 r0 *1 0,0
RTS_SNS_t0 TS_SNS__t0 TS_SNS 581.172968762
* device instance TS_SNS_t1 r0 *1 0,0
RTS_SNS_t1 TS_SNS__t1 TS_SNS 2417.94327627
* device instance TS_SNS_t2 r0 *1 0,0
RTS_SNS_t2 TS_SNS__t2 TS_SNS 1095.60037748
* device instance TS_SNS_t3 r0 *1 0,0
RTS_SNS_t3 TS_SNS__t3 TS_SNS 1095.60037748
* device instance TS_SNS r0 *1 0,0
CTS_SNS TS_SNS vsubs 3.4500218e-14
* device instance VIN_t0 r0 *1 0,0
RVIN_t0 VIN__t0 VIN 29437.4047527
* device instance VIN_t1 r0 *1 0,0
RVIN_t1 VIN__t1 VIN 2184.27937804
* device instance VIN_t2 r0 *1 0,0
RVIN_t2 VIN__t2 VIN 2184.27937804
* device instance VIN_t3 r0 *1 0,0
RVIN_t3 VIN__t3 VIN 2114.98697926
* device instance VIN_t4 r0 *1 0,0
RVIN_t4 VIN__t4 VIN 2114.98697926
* device instance VIN_t5 r0 *1 0,0
RVIN_t5 VIN__t5 VIN 2008.37441878
* device instance VIN_t6 r0 *1 0,0
RVIN_t6 VIN__t6 VIN 2008.37441878
* device instance VIN_t7 r0 *1 0,0
RVIN_t7 VIN__t7 VIN 1711.44942088
* device instance VIN_t8 r0 *1 0,0
RVIN_t8 VIN__t8 VIN 1711.44942088
* device instance VIN_t9 r0 *1 0,0
RVIN_t9 VIN__t9 VIN 1690.71440488
* device instance VIN_t10 r0 *1 0,0
RVIN_t10 VIN__t10 VIN 1463.36008251
* device instance VIN_t11 r0 *1 0,0
RVIN_t11 VIN__t11 VIN 1463.36008251
* device instance VIN_t12 r0 *1 0,0
RVIN_t12 VIN__t12 VIN 1243.6632738
* device instance VIN_t13 r0 *1 0,0
RVIN_t13 VIN__t13 VIN 1243.6632738
* device instance VIN_t14 r0 *1 0,0
RVIN_t14 VIN__t14 VIN 1030.70239013
* device instance VIN_t15 r0 *1 0,0
RVIN_t15 VIN__t15 VIN 1030.70239013
* device instance VIN_t16 r0 *1 0,0
RVIN_t16 VIN__t16 VIN 965.196117766
* device instance VIN_t17 r0 *1 0,0
RVIN_t17 VIN__t17 VIN 965.196117766
* device instance VIN_t18 r0 *1 0,0
RVIN_t18 VIN__t18 VIN 865.191669722
* device instance VIN_t19 r0 *1 0,0
RVIN_t19 VIN__t19 VIN 865.191669722
* device instance VIN_t20 r0 *1 0,0
RVIN_t20 VIN__t20 VIN 775.261221406
* device instance VIN_t21 r0 *1 0,0
RVIN_t21 VIN__t21 VIN 775.261221406
* device instance VIN_t22 r0 *1 0,0
RVIN_t22 VIN__t22 VIN 640.745218125
* device instance VIN_t23 r0 *1 0,0
RVIN_t23 VIN__t23 VIN 640.745218125
* device instance VIN_t24 r0 *1 0,0
RVIN_t24 VIN__t24 VIN 258.911051619
* device instance VIN_t25 r0 *1 0,0
RVIN_t25 VIN__t25 VIN 258.911051619
* device instance VIN_t26 r0 *1 0,0
RVIN_t26 VIN__t26 VIN 492.610377175
* device instance VIN_t27 r0 *1 0,0
RVIN_t27 VIN__t27 VIN 548.368262221
* device instance VIN_t28 r0 *1 0,0
RVIN_t28 VIN__t28 VIN 576.915427608
* device instance VIN_t29 r0 *1 0,0
RVIN_t29 VIN__t29 VIN 605.824441713
* device instance VIN_t30 r0 *1 0,0
RVIN_t30 VIN__t30 VIN 635.045889449
* device instance VIN_t31 r0 *1 0,0
RVIN_t31 VIN__t31 VIN 664.538556593
* device instance VIN_t32 r0 *1 0,0
RVIN_t32 VIN__t32 VIN 694.267879608
* device instance VIN_t33 r0 *1 0,0
RVIN_t33 VIN__t33 VIN 724.204714204
* device instance VIN_t34 r0 *1 0,0
RVIN_t34 VIN__t34 VIN 754.32435428
* device instance VIN_t35 r0 *1 0,0
RVIN_t35 VIN__t35 VIN 784.605747371
* device instance VIN_t36 r0 *1 0,0
RVIN_t36 VIN__t36 VIN 845.584191784
* device instance VIN_t37 r0 *1 0,0
RVIN_t37 VIN__t37 VIN 520.242515923
* device instance VIN_t38 r0 *1 0,0
RVIN_t38 VIN__t38 VIN 465.559744813
* device instance VIN_t39 r0 *1 0,0
RVIN_t39 VIN__t39 VIN 439.198078598
* device instance VIN_t40 r0 *1 0,0
RVIN_t40 VIN__t40 VIN 413.657119439
* device instance VIN_t41 r0 *1 0,0
RVIN_t41 VIN__t41 VIN 389.098517915
* device instance VIN_t42 r0 *1 0,0
RVIN_t42 VIN__t42 VIN 365.720227482
* device instance VIN_t43 r0 *1 0,0
RVIN_t43 VIN__t43 VIN 343.763140692
* device instance VIN_t44 r0 *1 0,0
RVIN_t44 VIN__t44 VIN 305.32158949
* device instance VIN_t45 r0 *1 0,0
RVIN_t45 VIN__t45 VIN 289.564564492
* device instance VIN_t46 r0 *1 0,0
RVIN_t46 VIN__t46 VIN 276.662583256
* device instance VIN_t47 r0 *1 0,0
RVIN_t47 VIN__t47 VIN 267.02980527
* device instance VIN_t48 r0 *1 0,0
RVIN_t48 VIN__t48 VIN 261.028413768
* device instance VIN_t49 r0 *1 0,0
RVIN_t49 VIN__t49 VIN 815.030864519
* device instance VIN_t50 r0 *1 0,0
RVIN_t50 VIN__t50 VIN 323.516758409
* device instance VIN_t51 r0 *1 0,0
RVIN_t51 VIN__t51 VIN 1597.86212833
* device instance VIN_t52 r0 *1 0,0
RVIN_t52 VIN__t52 VIN 1566.13845197
* device instance VIN_t53 r0 *1 0,0
RVIN_t53 VIN__t53 VIN 1534.43282821
* device instance VIN_t54 r0 *1 0,0
RVIN_t54 VIN__t54 VIN 1502.7463997
* device instance VIN_t55 r0 *1 0,0
RVIN_t55 VIN__t55 VIN 1471.08040681
* device instance VIN_t56 r0 *1 0,0
RVIN_t56 VIN__t56 VIN 1439.43619822
* device instance VIN_t57 r0 *1 0,0
RVIN_t57 VIN__t57 VIN 1407.81524291
* device instance VIN_t58 r0 *1 0,0
RVIN_t58 VIN__t58 VIN 1376.21914372
* device instance VIN_t59 r0 *1 0,0
RVIN_t59 VIN__t59 VIN 1344.64965284
* device instance VIN_t60 r0 *1 0,0
RVIN_t60 VIN__t60 VIN 1313.1086894
* device instance VIN_t61 r0 *1 0,0
RVIN_t61 VIN__t61 VIN 1281.59835965
* device instance VIN_t62 r0 *1 0,0
RVIN_t62 VIN__t62 VIN 1250.12098002
* device instance VIN_t63 r0 *1 0,0
RVIN_t63 VIN__t63 VIN 876.252317905
* device instance VIN_t64 r0 *1 0,0
RVIN_t64 VIN__t64 VIN 907.02359828
* device instance VIN_t65 r0 *1 0,0
RVIN_t65 VIN__t65 VIN 937.887879762
* device instance VIN_t66 r0 *1 0,0
RVIN_t66 VIN__t66 VIN 968.836274163
* device instance VIN_t67 r0 *1 0,0
RVIN_t67 VIN__t67 VIN 999.86097095
* device instance VIN_t68 r0 *1 0,0
RVIN_t68 VIN__t68 VIN 1030.95508161
* device instance VIN_t69 r0 *1 0,0
RVIN_t69 VIN__t69 VIN 1062.11250972
* device instance VIN_t70 r0 *1 0,0
RVIN_t70 VIN__t70 VIN 1093.32784209
* device instance VIN_t71 r0 *1 0,0
RVIN_t71 VIN__t71 VIN 1124.59625699
* device instance VIN_t72 r0 *1 0,0
RVIN_t72 VIN__t72 VIN 1155.91344666
* device instance VIN_t73 r0 *1 0,0
RVIN_t73 VIN__t73 VIN 1187.27555144
* device instance VIN_t74 r0 *1 0,0
RVIN_t74 VIN__t74 VIN 1218.67910373
* device instance VIN_t75 r0 *1 0,0
RVIN_t75 VIN__t75 VIN 492.610377175
* device instance VIN_t76 r0 *1 0,0
RVIN_t76 VIN__t76 VIN 548.368262221
* device instance VIN_t77 r0 *1 0,0
RVIN_t77 VIN__t77 VIN 576.915427608
* device instance VIN_t78 r0 *1 0,0
RVIN_t78 VIN__t78 VIN 605.824441713
* device instance VIN_t79 r0 *1 0,0
RVIN_t79 VIN__t79 VIN 635.045889449
* device instance VIN_t80 r0 *1 0,0
RVIN_t80 VIN__t80 VIN 664.538556593
* device instance VIN_t81 r0 *1 0,0
RVIN_t81 VIN__t81 VIN 694.267879608
* device instance VIN_t82 r0 *1 0,0
RVIN_t82 VIN__t82 VIN 724.204714204
* device instance VIN_t83 r0 *1 0,0
RVIN_t83 VIN__t83 VIN 754.32435428
* device instance VIN_t84 r0 *1 0,0
RVIN_t84 VIN__t84 VIN 784.605747371
* device instance VIN_t85 r0 *1 0,0
RVIN_t85 VIN__t85 VIN 845.584191784
* device instance VIN_t86 r0 *1 0,0
RVIN_t86 VIN__t86 VIN 520.242515923
* device instance VIN_t87 r0 *1 0,0
RVIN_t87 VIN__t87 VIN 465.559744813
* device instance VIN_t88 r0 *1 0,0
RVIN_t88 VIN__t88 VIN 439.198078598
* device instance VIN_t89 r0 *1 0,0
RVIN_t89 VIN__t89 VIN 413.657119439
* device instance VIN_t90 r0 *1 0,0
RVIN_t90 VIN__t90 VIN 389.098517915
* device instance VIN_t91 r0 *1 0,0
RVIN_t91 VIN__t91 VIN 365.720227482
* device instance VIN_t92 r0 *1 0,0
RVIN_t92 VIN__t92 VIN 343.763140692
* device instance VIN_t93 r0 *1 0,0
RVIN_t93 VIN__t93 VIN 305.32158949
* device instance VIN_t94 r0 *1 0,0
RVIN_t94 VIN__t94 VIN 289.564564492
* device instance VIN_t95 r0 *1 0,0
RVIN_t95 VIN__t95 VIN 276.662583256
* device instance VIN_t96 r0 *1 0,0
RVIN_t96 VIN__t96 VIN 267.02980527
* device instance VIN_t97 r0 *1 0,0
RVIN_t97 VIN__t97 VIN 261.028413768
* device instance VIN_t98 r0 *1 0,0
RVIN_t98 VIN__t98 VIN 815.030864519
* device instance VIN_t99 r0 *1 0,0
RVIN_t99 VIN__t99 VIN 323.516758409
* device instance VIN_t100 r0 *1 0,0
RVIN_t100 VIN__t100 VIN 1597.86212833
* device instance VIN_t101 r0 *1 0,0
RVIN_t101 VIN__t101 VIN 1566.13845197
* device instance VIN_t102 r0 *1 0,0
RVIN_t102 VIN__t102 VIN 1534.43282821
* device instance VIN_t103 r0 *1 0,0
RVIN_t103 VIN__t103 VIN 1502.7463997
* device instance VIN_t104 r0 *1 0,0
RVIN_t104 VIN__t104 VIN 1471.08040681
* device instance VIN_t105 r0 *1 0,0
RVIN_t105 VIN__t105 VIN 1439.43619822
* device instance VIN_t106 r0 *1 0,0
RVIN_t106 VIN__t106 VIN 1407.81524291
* device instance VIN_t107 r0 *1 0,0
RVIN_t107 VIN__t107 VIN 1376.21914372
* device instance VIN_t108 r0 *1 0,0
RVIN_t108 VIN__t108 VIN 1344.64965284
* device instance VIN_t109 r0 *1 0,0
RVIN_t109 VIN__t109 VIN 1313.1086894
* device instance VIN_t110 r0 *1 0,0
RVIN_t110 VIN__t110 VIN 1281.59835965
* device instance VIN_t111 r0 *1 0,0
RVIN_t111 VIN__t111 VIN 1250.12098002
* device instance VIN_t112 r0 *1 0,0
RVIN_t112 VIN__t112 VIN 876.252317905
* device instance VIN_t113 r0 *1 0,0
RVIN_t113 VIN__t113 VIN 907.02359828
* device instance VIN_t114 r0 *1 0,0
RVIN_t114 VIN__t114 VIN 937.887879762
* device instance VIN_t115 r0 *1 0,0
RVIN_t115 VIN__t115 VIN 968.836274163
* device instance VIN_t116 r0 *1 0,0
RVIN_t116 VIN__t116 VIN 999.86097095
* device instance VIN_t117 r0 *1 0,0
RVIN_t117 VIN__t117 VIN 1030.95508161
* device instance VIN_t118 r0 *1 0,0
RVIN_t118 VIN__t118 VIN 1062.11250972
* device instance VIN_t119 r0 *1 0,0
RVIN_t119 VIN__t119 VIN 1093.32784209
* device instance VIN_t120 r0 *1 0,0
RVIN_t120 VIN__t120 VIN 1124.59625699
* device instance VIN_t121 r0 *1 0,0
RVIN_t121 VIN__t121 VIN 1155.91344666
* device instance VIN_t122 r0 *1 0,0
RVIN_t122 VIN__t122 VIN 1187.27555144
* device instance VIN_t123 r0 *1 0,0
RVIN_t123 VIN__t123 VIN 1218.67910373
* device instance VIN_t124 r0 *1 0,0
RVIN_t124 VIN__t124 VIN 531.918338737
* device instance VIN_t125 r0 *1 0,0
RVIN_t125 VIN__t125 VIN 531.918338737
* device instance VIN_t126 r0 *1 0,0
RVIN_t126 VIN__t126 VIN 701.254309204
* device instance VIN_t127 r0 *1 0,0
RVIN_t127 VIN__t127 VIN 651.082315661
* device instance VIN_t128 r0 *1 0,0
RVIN_t128 VIN__t128 VIN 1339.4160655
* device instance VIN_t129 r0 *1 0,0
RVIN_t129 VIN__t129 VIN 1339.4160655
* device instance VIN_t130 r0 *1 0,0
RVIN_t130 VIN__t130 VIN 701.254309204
* device instance VIN_t131 r0 *1 0,0
RVIN_t131 VIN__t131 VIN 651.082315661
* device instance VIN_t132 r0 *1 0,0
RVIN_t132 VIN__t132 VIN 1272.97417669
* device instance VIN_t133 r0 *1 0,0
RVIN_t133 VIN__t133 VIN 1601.66097585
* device instance VIN_t134 r0 *1 0,0
RVIN_t134 VIN__t134 VIN 1944.80605903
* device instance VIN_t135 r0 *1 0,0
RVIN_t135 VIN__t135 VIN 1881.49524136
* device instance VIN_t136 r0 *1 0,0
RVIN_t136 VIN__t136 VIN 1063.78334042
* device instance VIN_t137 r0 *1 0,0
RVIN_t137 VIN__t137 VIN 1944.80605903
* device instance VIN_t138 r0 *1 0,0
RVIN_t138 VIN__t138 VIN 1881.49524136
* device instance VIN_t139 r0 *1 0,0
RVIN_t139 VIN__t139 VIN 650.053165258
* device instance VIN_t140 r0 *1 0,0
RVIN_t140 VIN__t140 VIN 1063.78334042
* device instance VIN_t141 r0 *1 0,0
RVIN_t141 VIN__t141 VIN 2050.30994096
* device instance VIN_t142 r0 *1 0,0
RVIN_t142 VIN__t142 VIN 2050.30994096
* device instance VIN_t143 r0 *1 0,0
RVIN_t143 VIN__t143 VIN 1138.39729827
* device instance VIN_t144 r0 *1 0,0
RVIN_t144 VIN__t144 VIN 1138.39729827
* device instance VIN r0 *1 0,0
CVIN VIN vsubs 7.43164076e-13
* device instance VOUT_t0 r0 *1 0,0
RVOUT_t0 VOUT__t0 VOUT 64331.8692037
* device instance VOUT_t1 r0 *1 0,0
RVOUT_t1 VOUT__t1 VOUT 2241.14185406
* device instance VOUT_t2 r0 *1 0,0
RVOUT_t2 VOUT__t2 VOUT 378.676610988
* device instance VOUT_t3 r0 *1 0,0
RVOUT_t3 VOUT__t3 VOUT 115.411941088
* device instance VOUT_t4 r0 *1 0,0
RVOUT_t4 VOUT__t4 VOUT 101.689501825
* device instance VOUT_t5 r0 *1 0,0
RVOUT_t5 VOUT__t5 VOUT 220.758176207
* device instance VOUT_t6 r0 *1 0,0
RVOUT_t6 VOUT__t6 VOUT 358.469202148
* device instance VOUT_t7 r0 *1 0,0
RVOUT_t7 VOUT__t7 VOUT 499.63861376
* device instance VOUT_t8 r0 *1 0,0
RVOUT_t8 VOUT__t8 VOUT 641.989017644
* device instance VOUT_t9 r0 *1 0,0
RVOUT_t9 VOUT__t9 VOUT 784.878100177
* device instance VOUT_t10 r0 *1 0,0
RVOUT_t10 VOUT__t10 VOUT 928.05708038
* device instance VOUT_t11 r0 *1 0,0
RVOUT_t11 VOUT__t11 VOUT 1071.40974221
* device instance VOUT_t12 r0 *1 0,0
RVOUT_t12 VOUT__t12 VOUT 1358.41611998
* device instance VOUT_t13 r0 *1 0,0
RVOUT_t13 VOUT__t13 VOUT 240.149237881
* device instance VOUT_t14 r0 *1 0,0
RVOUT_t14 VOUT__t14 VOUT 520.089294169
* device instance VOUT_t15 r0 *1 0,0
RVOUT_t15 VOUT__t15 VOUT 662.542339065
* device instance VOUT_t16 r0 *1 0,0
RVOUT_t16 VOUT__t16 VOUT 805.48395834
* device instance VOUT_t17 r0 *1 0,0
RVOUT_t17 VOUT__t17 VOUT 948.693334106
* device instance VOUT_t18 r0 *1 0,0
RVOUT_t18 VOUT__t18 VOUT 1092.06513366
* device instance VOUT_t19 r0 *1 0,0
RVOUT_t19 VOUT__t19 VOUT 1235.54281556
* device instance VOUT_t20 r0 *1 0,0
RVOUT_t20 VOUT__t20 VOUT 1522.69608648
* device instance VOUT_t21 r0 *1 0,0
RVOUT_t21 VOUT__t21 VOUT 1666.3375713
* device instance VOUT_t22 r0 *1 0,0
RVOUT_t22 VOUT__t22 VOUT 1810.00856634
* device instance VOUT_t23 r0 *1 0,0
RVOUT_t23 VOUT__t23 VOUT 1953.70256126
* device instance VOUT_t24 r0 *1 0,0
RVOUT_t24 VOUT__t24 VOUT 2097.4148289
* device instance VOUT_t25 r0 *1 0,0
RVOUT_t25 VOUT__t25 VOUT 1214.87460501
* device instance VOUT_t26 r0 *1 0,0
RVOUT_t26 VOUT__t26 VOUT 1379.09333294
* device instance VOUT_t27 r0 *1 0,0
RVOUT_t27 VOUT__t27 VOUT 4808.538782
* device instance VOUT_t28 r0 *1 0,0
RVOUT_t28 VOUT__t28 VOUT 4664.7324976
* device instance VOUT_t29 r0 *1 0,0
RVOUT_t29 VOUT__t29 VOUT 4520.92754966
* device instance VOUT_t30 r0 *1 0,0
RVOUT_t30 VOUT__t30 VOUT 4377.1240699
* device instance VOUT_t31 r0 *1 0,0
RVOUT_t31 VOUT__t31 VOUT 4233.32220795
* device instance VOUT_t32 r0 *1 0,0
RVOUT_t32 VOUT__t32 VOUT 4089.52213447
* device instance VOUT_t33 r0 *1 0,0
RVOUT_t33 VOUT__t33 VOUT 3945.72404499
* device instance VOUT_t34 r0 *1 0,0
RVOUT_t34 VOUT__t34 VOUT 3801.92816463
* device instance VOUT_t35 r0 *1 0,0
RVOUT_t35 VOUT__t35 VOUT 3658.13475392
* device instance VOUT_t36 r0 *1 0,0
RVOUT_t36 VOUT__t36 VOUT 3514.34411599
* device instance VOUT_t37 r0 *1 0,0
RVOUT_t37 VOUT__t37 VOUT 3370.5566057
* device instance VOUT_t38 r0 *1 0,0
RVOUT_t38 VOUT__t38 VOUT 3226.77264118
* device instance VOUT_t39 r0 *1 0,0
RVOUT_t39 VOUT__t39 VOUT 1502.01231124
* device instance VOUT_t40 r0 *1 0,0
RVOUT_t40 VOUT__t40 VOUT 1645.648866
* device instance VOUT_t41 r0 *1 0,0
RVOUT_t41 VOUT__t41 VOUT 1789.31606379
* device instance VOUT_t42 r0 *1 0,0
RVOUT_t42 VOUT__t42 VOUT 1933.00707217
* device instance VOUT_t43 r0 *1 0,0
RVOUT_t43 VOUT__t43 VOUT 2076.71694868
* device instance VOUT_t44 r0 *1 0,0
RVOUT_t44 VOUT__t44 VOUT 2220.44202981
* device instance VOUT_t45 r0 *1 0,0
RVOUT_t45 VOUT__t45 VOUT 2364.17954257
* device instance VOUT_t46 r0 *1 0,0
RVOUT_t46 VOUT__t46 VOUT 2507.92734946
* device instance VOUT_t47 r0 *1 0,0
RVOUT_t47 VOUT__t47 VOUT 2651.68377637
* device instance VOUT_t48 r0 *1 0,0
RVOUT_t48 VOUT__t48 VOUT 2795.44749341
* device instance VOUT_t49 r0 *1 0,0
RVOUT_t49 VOUT__t49 VOUT 2939.21743088
* device instance VOUT_t50 r0 *1 0,0
RVOUT_t50 VOUT__t50 VOUT 3082.99271852
* device instance VOUT r0 *1 0,0
CVOUT VOUT vsubs 5.90325101e-13
* device instance VREF_t0 r0 *1 0,0
RVREF_t0 VREF__t0 VREF 258.5884
* device instance VREF r0 *1 0,0
CVREF VREF vsubs 3.485392e-15
* device instance cc_0_AMP_ENN r0 *1 0,0
Ccc_0_AMP_ENN 0 AMP_ENN 4.5566e-17
* device instance cc_0_BIASP r0 *1 0,0
Ccc_0_BIASP 0 BIASP 6.509e-18
* device instance cc_0_BIAS_ENN r0 *1 0,0
Ccc_0_BIAS_ENN 0 BIAS_ENN 1.9528e-17
* device instance cc_0_CL_CMP r0 *1 0,0
Ccc_0_CL_CMP 0 CL_CMP 6.509e-18
* device instance cc_0_CL_SNS r0 *1 0,0
Ccc_0_CL_SNS 0 CL_SNS 3.0604e-17
* device instance cc_0_EA_CZ r0 *1 0,0
Ccc_0_EA_CZ 0 EA_CZ 6.509e-18
* device instance cc_0_EA_D1 r0 *1 0,0
Ccc_0_EA_D1 0 EA_D1 3.0604e-17
* device instance cc_0_EA_D2 r0 *1 0,0
Ccc_0_EA_D2 0 EA_D2 3.0604e-17
* device instance cc_0_EA_OUT r0 *1 0,0
Ccc_0_EA_OUT 0 EA_OUT 1.3019e-17
* device instance cc_0_EN r0 *1 0,0
Ccc_0_EN 0 EN 3.6142e-17
* device instance cc_0_ENB r0 *1 0,0
Ccc_0_ENB 0 ENB 6.509e-18
* device instance cc_0_FB r0 *1 0,0
Ccc_0_FB 0 FB 3.9056e-17
* device instance cc_0_NB r0 *1 0,0
Ccc_0_NB 0 NB 3.9056e-17
* device instance cc_0_PB r0 *1 0,0
Ccc_0_PB 0 PB 6.509e-18
* device instance cc_0_VIN r0 *1 0,0
Ccc_0_VIN 0 VIN 3.9056e-17
* device instance cc_0_VOUT r0 *1 0,0
Ccc_0_VOUT 0 VOUT 3.9056e-17
* device instance cc_AMP_ENN_BIASP r0 *1 0,0
Ccc_AMP_ENN_BIASP AMP_ENN BIASP 6.5094e-17
* device instance cc_AMP_ENN_CL_CMP r0 *1 0,0
Ccc_AMP_ENN_CL_CMP AMP_ENN CL_CMP 6.509e-18
* device instance cc_AMP_ENN_CL_SNS r0 *1 0,0
Ccc_AMP_ENN_CL_SNS AMP_ENN CL_SNS 3.0604e-17
* device instance cc_AMP_ENN_EA_D1 r0 *1 0,0
Ccc_AMP_ENN_EA_D1 AMP_ENN EA_D1 3.0604e-17
* device instance cc_AMP_ENN_EA_D2 r0 *1 0,0
Ccc_AMP_ENN_EA_D2 AMP_ENN EA_D2 3.0604e-17
* device instance cc_AMP_ENN_EA_OUT r0 *1 0,0
Ccc_AMP_ENN_EA_OUT AMP_ENN EA_OUT 6.5094e-17
* device instance cc_AMP_ENN_EN r0 *1 0,0
Ccc_AMP_ENN_EN AMP_ENN EN 6.5094e-17
* device instance cc_AMP_ENN_ENB r0 *1 0,0
Ccc_AMP_ENN_ENB AMP_ENN ENB 1.8557e-17
* device instance cc_AMP_ENN_FB r0 *1 0,0
Ccc_AMP_ENN_FB AMP_ENN FB 6.5094e-17
* device instance cc_AMP_ENN_NB r0 *1 0,0
Ccc_AMP_ENN_NB AMP_ENN NB 6.5094e-17
* device instance cc_AMP_ENN_PB r0 *1 0,0
Ccc_AMP_ENN_PB AMP_ENN PB 6.509e-18
* device instance cc_AMP_ENN_SS r0 *1 0,0
Ccc_AMP_ENN_SS AMP_ENN SS 6.509e-18
* device instance cc_AMP_ENN_TS_MID r0 *1 0,0
Ccc_AMP_ENN_TS_MID AMP_ENN TS_MID 2.5066e-17
* device instance cc_AMP_ENN_TS_REF r0 *1 0,0
Ccc_AMP_ENN_TS_REF AMP_ENN TS_REF 1.8557e-17
* device instance cc_AMP_ENN_TS_SNS r0 *1 0,0
Ccc_AMP_ENN_TS_SNS AMP_ENN TS_SNS 1.8557e-17
* device instance cc_AMP_ENN_VIN r0 *1 0,0
Ccc_AMP_ENN_VIN AMP_ENN VIN 6.5094e-17
* device instance cc_AMP_ENN_VOUT r0 *1 0,0
Ccc_AMP_ENN_VOUT AMP_ENN VOUT 6.5094e-17
* device instance cc_BIASP_CL_CMP r0 *1 0,0
Ccc_BIASP_CL_CMP BIASP CL_CMP 3.1576e-17
* device instance cc_BIASP_CL_SNS r0 *1 0,0
Ccc_BIASP_CL_SNS BIASP CL_SNS 3.7114e-17
* device instance cc_BIASP_EA_D1 r0 *1 0,0
Ccc_BIASP_EA_D1 BIASP EA_D1 3.7114e-17
* device instance cc_BIASP_EA_D2 r0 *1 0,0
Ccc_BIASP_EA_D2 BIASP EA_D2 4.3623e-17
* device instance cc_BIASP_EA_OUT r0 *1 0,0
Ccc_BIASP_EA_OUT BIASP EA_OUT 1.0386e-16
* device instance cc_BIASP_EA_TAIL r0 *1 0,0
Ccc_BIASP_EA_TAIL BIASP EA_TAIL 2.6038e-17
* device instance cc_BIASP_EN r0 *1 0,0
Ccc_BIASP_EN BIASP EN 5.567e-17
* device instance cc_BIASP_ENB r0 *1 0,0
Ccc_BIASP_ENB BIASP ENB 2.5066e-17
* device instance cc_BIASP_FB r0 *1 0,0
Ccc_BIASP_FB BIASP FB 4.3623e-17
* device instance cc_BIASP_NB r0 *1 0,0
Ccc_BIASP_NB BIASP NB 6.509e-18
* device instance cc_BIASP_PB r0 *1 0,0
Ccc_BIASP_PB BIASP PB 4.3623e-17
* device instance cc_BIASP_SS r0 *1 0,0
Ccc_BIASP_SS BIASP SS 2.5066e-17
* device instance cc_BIASP_TC_D1 r0 *1 0,0
Ccc_BIASP_TC_D1 BIASP TC_D1 3.7114e-17
* device instance cc_BIASP_TC_TAIL r0 *1 0,0
Ccc_BIASP_TC_TAIL BIASP TC_TAIL 1.9528e-17
* device instance cc_BIASP_TS_CMP r0 *1 0,0
Ccc_BIASP_TS_CMP BIASP TS_CMP 3.1576e-17
* device instance cc_BIASP_TS_MID r0 *1 0,0
Ccc_BIASP_TS_MID BIASP TS_MID 2.5066e-17
* device instance cc_BIASP_TS_REF r0 *1 0,0
Ccc_BIASP_TS_REF BIASP TS_REF 3.7114e-17
* device instance cc_BIASP_TS_SNS r0 *1 0,0
Ccc_BIASP_TS_SNS BIASP TS_SNS 3.7114e-17
* device instance cc_BIASP_VIN r0 *1 0,0
Ccc_BIASP_VIN BIASP VIN 1.0386e-16
* device instance cc_BIASP_VOUT r0 *1 0,0
Ccc_BIASP_VOUT BIASP VOUT 1.0386e-16
* device instance cc_BIASP_VREF r0 *1 0,0
Ccc_BIASP_VREF BIASP VREF 1.2047e-17
* device instance cc_BIAS_ENN_EA_OUT r0 *1 0,0
Ccc_BIAS_ENN_EA_OUT BIAS_ENN EA_OUT 1.9528e-17
* device instance cc_BIAS_ENN_EN r0 *1 0,0
Ccc_BIAS_ENN_EN BIAS_ENN EN 1.2047e-17
* device instance cc_BIAS_ENN_FB r0 *1 0,0
Ccc_BIAS_ENN_FB BIAS_ENN FB 1.9528e-17
* device instance cc_BIAS_ENN_NB r0 *1 0,0
Ccc_BIAS_ENN_NB BIAS_ENN NB 1.9528e-17
* device instance cc_BIAS_ENN_VIN r0 *1 0,0
Ccc_BIAS_ENN_VIN BIAS_ENN VIN 1.9528e-17
* device instance cc_BIAS_ENN_VOUT r0 *1 0,0
Ccc_BIAS_ENN_VOUT BIAS_ENN VOUT 1.9528e-17
* device instance cc_CL_CMP_CL_SNS r0 *1 0,0
Ccc_CL_CMP_CL_SNS CL_CMP CL_SNS 1.3019e-17
* device instance cc_CL_CMP_EA_D1 r0 *1 0,0
Ccc_CL_CMP_EA_D1 CL_CMP EA_D1 1.3019e-17
* device instance cc_CL_CMP_EA_D2 r0 *1 0,0
Ccc_CL_CMP_EA_D2 CL_CMP EA_D2 1.3019e-17
* device instance cc_CL_CMP_EA_OUT r0 *1 0,0
Ccc_CL_CMP_EA_OUT CL_CMP EA_OUT 3.1576e-17
* device instance cc_CL_CMP_EA_TAIL r0 *1 0,0
Ccc_CL_CMP_EA_TAIL CL_CMP EA_TAIL 2.6038e-17
* device instance cc_CL_CMP_EN r0 *1 0,0
Ccc_CL_CMP_EN CL_CMP EN 3.1576e-17
* device instance cc_CL_CMP_ENB r0 *1 0,0
Ccc_CL_CMP_ENB CL_CMP ENB 1.8557e-17
* device instance cc_CL_CMP_FB r0 *1 0,0
Ccc_CL_CMP_FB CL_CMP FB 1.3019e-17
* device instance cc_CL_CMP_NB r0 *1 0,0
Ccc_CL_CMP_NB CL_CMP NB 6.509e-18
* device instance cc_CL_CMP_PB r0 *1 0,0
Ccc_CL_CMP_PB CL_CMP PB 1.3019e-17
* device instance cc_CL_CMP_SS r0 *1 0,0
Ccc_CL_CMP_SS CL_CMP SS 1.8557e-17
* device instance cc_CL_CMP_TC_D1 r0 *1 0,0
Ccc_CL_CMP_TC_D1 CL_CMP TC_D1 6.509e-18
* device instance cc_CL_CMP_TC_TAIL r0 *1 0,0
Ccc_CL_CMP_TC_TAIL CL_CMP TC_TAIL 1.9528e-17
* device instance cc_CL_CMP_TS_CMP r0 *1 0,0
Ccc_CL_CMP_TS_CMP CL_CMP TS_CMP 1.3019e-17
* device instance cc_CL_CMP_TS_MID r0 *1 0,0
Ccc_CL_CMP_TS_MID CL_CMP TS_MID 2.5066e-17
* device instance cc_CL_CMP_TS_REF r0 *1 0,0
Ccc_CL_CMP_TS_REF CL_CMP TS_REF 3.0604e-17
* device instance cc_CL_CMP_TS_SNS r0 *1 0,0
Ccc_CL_CMP_TS_SNS CL_CMP TS_SNS 3.0604e-17
* device instance cc_CL_CMP_VIN r0 *1 0,0
Ccc_CL_CMP_VIN CL_CMP VIN 3.1576e-17
* device instance cc_CL_CMP_VOUT r0 *1 0,0
Ccc_CL_CMP_VOUT CL_CMP VOUT 3.1576e-17
* device instance cc_CL_CMP_VREF r0 *1 0,0
Ccc_CL_CMP_VREF CL_CMP VREF 1.2047e-17
* device instance cc_CL_SNS_EA_D1 r0 *1 0,0
Ccc_CL_SNS_EA_D1 CL_SNS EA_D1 3.0604e-17
* device instance cc_CL_SNS_EA_D2 r0 *1 0,0
Ccc_CL_SNS_EA_D2 CL_SNS EA_D2 3.0604e-17
* device instance cc_CL_SNS_EA_OUT r0 *1 0,0
Ccc_CL_SNS_EA_OUT CL_SNS EA_OUT 3.7114e-17
* device instance cc_CL_SNS_EA_TAIL r0 *1 0,0
Ccc_CL_SNS_EA_TAIL CL_SNS EA_TAIL 2.6038e-17
* device instance cc_CL_SNS_EN r0 *1 0,0
Ccc_CL_SNS_EN CL_SNS EN 3.7114e-17
* device instance cc_CL_SNS_ENB r0 *1 0,0
Ccc_CL_SNS_ENB CL_SNS ENB 1.8557e-17
* device instance cc_CL_SNS_FB r0 *1 0,0
Ccc_CL_SNS_FB CL_SNS FB 3.0604e-17
* device instance cc_CL_SNS_NB r0 *1 0,0
Ccc_CL_SNS_NB CL_SNS NB 3.0604e-17
* device instance cc_CL_SNS_PB r0 *1 0,0
Ccc_CL_SNS_PB CL_SNS PB 3.0604e-17
* device instance cc_CL_SNS_SS r0 *1 0,0
Ccc_CL_SNS_SS CL_SNS SS 1.8557e-17
* device instance cc_CL_SNS_TC_D1 r0 *1 0,0
Ccc_CL_SNS_TC_D1 CL_SNS TC_D1 6.509e-18
* device instance cc_CL_SNS_TC_TAIL r0 *1 0,0
Ccc_CL_SNS_TC_TAIL CL_SNS TC_TAIL 1.9528e-17
* device instance cc_CL_SNS_TS_CMP r0 *1 0,0
Ccc_CL_SNS_TS_CMP CL_SNS TS_CMP 1.3019e-17
* device instance cc_CL_SNS_TS_MID r0 *1 0,0
Ccc_CL_SNS_TS_MID CL_SNS TS_MID 2.5066e-17
* device instance cc_CL_SNS_TS_REF r0 *1 0,0
Ccc_CL_SNS_TS_REF CL_SNS TS_REF 3.0604e-17
* device instance cc_CL_SNS_TS_SNS r0 *1 0,0
Ccc_CL_SNS_TS_SNS CL_SNS TS_SNS 3.0604e-17
* device instance cc_CL_SNS_VIN r0 *1 0,0
Ccc_CL_SNS_VIN CL_SNS VIN 3.7114e-17
* device instance cc_CL_SNS_VOUT r0 *1 0,0
Ccc_CL_SNS_VOUT CL_SNS VOUT 3.7114e-17
* device instance cc_CL_SNS_VREF r0 *1 0,0
Ccc_CL_SNS_VREF CL_SNS VREF 1.2047e-17
* device instance cc_EA_CZ_FB r0 *1 0,0
Ccc_EA_CZ_FB EA_CZ FB 6.509e-18
* device instance cc_EA_CZ_NB r0 *1 0,0
Ccc_EA_CZ_NB EA_CZ NB 6.509e-18
* device instance cc_EA_CZ_VIN r0 *1 0,0
Ccc_EA_CZ_VIN EA_CZ VIN 6.509e-18
* device instance cc_EA_CZ_VOUT r0 *1 0,0
Ccc_EA_CZ_VOUT EA_CZ VOUT 6.509e-18
* device instance cc_EA_D1_EA_D2 r0 *1 0,0
Ccc_EA_D1_EA_D2 EA_D1 EA_D2 3.0604e-17
* device instance cc_EA_D1_EA_OUT r0 *1 0,0
Ccc_EA_D1_EA_OUT EA_D1 EA_OUT 3.7114e-17
* device instance cc_EA_D1_EA_TAIL r0 *1 0,0
Ccc_EA_D1_EA_TAIL EA_D1 EA_TAIL 1.3019e-17
* device instance cc_EA_D1_EN r0 *1 0,0
Ccc_EA_D1_EN EA_D1 EN 3.7114e-17
* device instance cc_EA_D1_ENB r0 *1 0,0
Ccc_EA_D1_ENB EA_D1 ENB 1.8557e-17
* device instance cc_EA_D1_FB r0 *1 0,0
Ccc_EA_D1_FB EA_D1 FB 3.0604e-17
* device instance cc_EA_D1_NB r0 *1 0,0
Ccc_EA_D1_NB EA_D1 NB 3.0604e-17
* device instance cc_EA_D1_PB r0 *1 0,0
Ccc_EA_D1_PB EA_D1 PB 1.3019e-17
* device instance cc_EA_D1_SS r0 *1 0,0
Ccc_EA_D1_SS EA_D1 SS 6.509e-18
* device instance cc_EA_D1_TC_D1 r0 *1 0,0
Ccc_EA_D1_TC_D1 EA_D1 TC_D1 6.509e-18
* device instance cc_EA_D1_TC_TAIL r0 *1 0,0
Ccc_EA_D1_TC_TAIL EA_D1 TC_TAIL 1.9528e-17
* device instance cc_EA_D1_TS_CMP r0 *1 0,0
Ccc_EA_D1_TS_CMP EA_D1 TS_CMP 1.3019e-17
* device instance cc_EA_D1_TS_MID r0 *1 0,0
Ccc_EA_D1_TS_MID EA_D1 TS_MID 2.5066e-17
* device instance cc_EA_D1_TS_REF r0 *1 0,0
Ccc_EA_D1_TS_REF EA_D1 TS_REF 3.0604e-17
* device instance cc_EA_D1_TS_SNS r0 *1 0,0
Ccc_EA_D1_TS_SNS EA_D1 TS_SNS 3.0604e-17
* device instance cc_EA_D1_VIN r0 *1 0,0
Ccc_EA_D1_VIN EA_D1 VIN 3.7114e-17
* device instance cc_EA_D1_VOUT r0 *1 0,0
Ccc_EA_D1_VOUT EA_D1 VOUT 3.7114e-17
* device instance cc_EA_D2_EA_OUT r0 *1 0,0
Ccc_EA_D2_EA_OUT EA_D2 EA_OUT 4.3623e-17
* device instance cc_EA_D2_EA_TAIL r0 *1 0,0
Ccc_EA_D2_EA_TAIL EA_D2 EA_TAIL 2.6038e-17
* device instance cc_EA_D2_EN r0 *1 0,0
Ccc_EA_D2_EN EA_D2 EN 4.3623e-17
* device instance cc_EA_D2_ENB r0 *1 0,0
Ccc_EA_D2_ENB EA_D2 ENB 1.8557e-17
* device instance cc_EA_D2_FB r0 *1 0,0
Ccc_EA_D2_FB EA_D2 FB 3.0604e-17
* device instance cc_EA_D2_NB r0 *1 0,0
Ccc_EA_D2_NB EA_D2 NB 3.0604e-17
* device instance cc_EA_D2_PB r0 *1 0,0
Ccc_EA_D2_PB EA_D2 PB 4.3623e-17
* device instance cc_EA_D2_SS r0 *1 0,0
Ccc_EA_D2_SS EA_D2 SS 1.8557e-17
* device instance cc_EA_D2_TC_D1 r0 *1 0,0
Ccc_EA_D2_TC_D1 EA_D2 TC_D1 6.509e-18
* device instance cc_EA_D2_TC_TAIL r0 *1 0,0
Ccc_EA_D2_TC_TAIL EA_D2 TC_TAIL 1.9528e-17
* device instance cc_EA_D2_TS_CMP r0 *1 0,0
Ccc_EA_D2_TS_CMP EA_D2 TS_CMP 1.3019e-17
* device instance cc_EA_D2_TS_MID r0 *1 0,0
Ccc_EA_D2_TS_MID EA_D2 TS_MID 2.5066e-17
* device instance cc_EA_D2_TS_REF r0 *1 0,0
Ccc_EA_D2_TS_REF EA_D2 TS_REF 3.0604e-17
* device instance cc_EA_D2_TS_SNS r0 *1 0,0
Ccc_EA_D2_TS_SNS EA_D2 TS_SNS 3.0604e-17
* device instance cc_EA_D2_VIN r0 *1 0,0
Ccc_EA_D2_VIN EA_D2 VIN 4.3623e-17
* device instance cc_EA_D2_VOUT r0 *1 0,0
Ccc_EA_D2_VOUT EA_D2 VOUT 4.3623e-17
* device instance cc_EA_D2_VREF r0 *1 0,0
Ccc_EA_D2_VREF EA_D2 VREF 1.2047e-17
* device instance cc_EA_OUT_EA_TAIL r0 *1 0,0
Ccc_EA_OUT_EA_TAIL EA_OUT EA_TAIL 2.6038e-17
* device instance cc_EA_OUT_EN r0 *1 0,0
Ccc_EA_OUT_EN EA_OUT EN 1.08427e-16
* device instance cc_EA_OUT_ENB r0 *1 0,0
Ccc_EA_OUT_ENB EA_OUT ENB 2.5066e-17
* device instance cc_EA_OUT_FB r0 *1 0,0
Ccc_EA_OUT_FB EA_OUT FB 1.9528e-17
* device instance cc_EA_OUT_NB r0 *1 0,0
Ccc_EA_OUT_NB EA_OUT NB 1.3019e-17
* device instance cc_EA_OUT_PB r0 *1 0,0
Ccc_EA_OUT_PB EA_OUT PB 4.3623e-17
* device instance cc_EA_OUT_SS r0 *1 0,0
Ccc_EA_OUT_SS EA_OUT SS 2.5066e-17
* device instance cc_EA_OUT_TC_D1 r0 *1 0,0
Ccc_EA_OUT_TC_D1 EA_OUT TC_D1 3.7114e-17
* device instance cc_EA_OUT_TC_TAIL r0 *1 0,0
Ccc_EA_OUT_TC_TAIL EA_OUT TC_TAIL 1.9528e-17
* device instance cc_EA_OUT_TS_CMP r0 *1 0,0
Ccc_EA_OUT_TS_CMP EA_OUT TS_CMP 4.3623e-17
* device instance cc_EA_OUT_TS_HYS r0 *1 0,0
Ccc_EA_OUT_TS_HYS EA_OUT TS_HYS 1.3019e-17
* device instance cc_EA_OUT_TS_MID r0 *1 0,0
Ccc_EA_OUT_TS_MID EA_OUT TS_MID 2.5066e-17
* device instance cc_EA_OUT_TS_REF r0 *1 0,0
Ccc_EA_OUT_TS_REF EA_OUT TS_REF 4.3623e-17
* device instance cc_EA_OUT_TS_SNS r0 *1 0,0
Ccc_EA_OUT_TS_SNS EA_OUT TS_SNS 3.7114e-17
* device instance cc_EA_OUT_VIN r0 *1 0,0
Ccc_EA_OUT_VIN EA_OUT VIN 6.41426e-16
* device instance cc_EA_OUT_VOUT r0 *1 0,0
Ccc_EA_OUT_VOUT EA_OUT VOUT 6.53474e-16
* device instance cc_EA_OUT_VREF r0 *1 0,0
Ccc_EA_OUT_VREF EA_OUT VREF 1.2047e-17
* device instance cc_EA_TAIL_EN r0 *1 0,0
Ccc_EA_TAIL_EN EA_TAIL EN 2.6038e-17
* device instance cc_EA_TAIL_ENB r0 *1 0,0
Ccc_EA_TAIL_ENB EA_TAIL ENB 2.6038e-17
* device instance cc_EA_TAIL_FB r0 *1 0,0
Ccc_EA_TAIL_FB EA_TAIL FB 1.3019e-17
* device instance cc_EA_TAIL_PB r0 *1 0,0
Ccc_EA_TAIL_PB EA_TAIL PB 1.9528e-17
* device instance cc_EA_TAIL_SS r0 *1 0,0
Ccc_EA_TAIL_SS EA_TAIL SS 2.6038e-17
* device instance cc_EA_TAIL_TC_D1 r0 *1 0,0
Ccc_EA_TAIL_TC_D1 EA_TAIL TC_D1 2.6038e-17
* device instance cc_EA_TAIL_TS_CMP r0 *1 0,0
Ccc_EA_TAIL_TS_CMP EA_TAIL TS_CMP 2.6038e-17
* device instance cc_EA_TAIL_TS_REF r0 *1 0,0
Ccc_EA_TAIL_TS_REF EA_TAIL TS_REF 2.6038e-17
* device instance cc_EA_TAIL_TS_SNS r0 *1 0,0
Ccc_EA_TAIL_TS_SNS EA_TAIL TS_SNS 2.6038e-17
* device instance cc_EA_TAIL_VIN r0 *1 0,0
Ccc_EA_TAIL_VIN EA_TAIL VIN 2.6038e-17
* device instance cc_EA_TAIL_VOUT r0 *1 0,0
Ccc_EA_TAIL_VOUT EA_TAIL VOUT 2.6038e-17
* device instance cc_EA_TAIL_VREF r0 *1 0,0
Ccc_EA_TAIL_VREF EA_TAIL VREF 1.2047e-17
* device instance cc_EN_ENB r0 *1 0,0
Ccc_EN_ENB EN ENB 1.8557e-17
* device instance cc_EN_FB r0 *1 0,0
Ccc_EN_FB EN FB 9.6379e-17
* device instance cc_EN_NB r0 *1 0,0
Ccc_EN_NB EN NB 3.6142e-17
* device instance cc_EN_PB r0 *1 0,0
Ccc_EN_PB EN PB 4.3623e-17
* device instance cc_EN_SS r0 *1 0,0
Ccc_EN_SS EN SS 1.8557e-17
* device instance cc_EN_TC_D1 r0 *1 0,0
Ccc_EN_TC_D1 EN TC_D1 6.509e-18
* device instance cc_EN_TC_TAIL r0 *1 0,0
Ccc_EN_TC_TAIL EN TC_TAIL 1.9528e-17
* device instance cc_EN_TS_CMP r0 *1 0,0
Ccc_EN_TS_CMP EN TS_CMP 1.3019e-17
* device instance cc_EN_TS_MID r0 *1 0,0
Ccc_EN_TS_MID EN TS_MID 2.5066e-17
* device instance cc_EN_TS_REF r0 *1 0,0
Ccc_EN_TS_REF EN TS_REF 3.0604e-17
* device instance cc_EN_TS_SNS r0 *1 0,0
Ccc_EN_TS_SNS EN TS_SNS 3.0604e-17
* device instance cc_EN_VIN r0 *1 0,0
Ccc_EN_VIN EN VIN 1.08427e-16
* device instance cc_EN_VOUT r0 *1 0,0
Ccc_EN_VOUT EN VOUT 1.08427e-16
* device instance cc_EN_VREF r0 *1 0,0
Ccc_EN_VREF EN VREF 1.2047e-17
* device instance cc_ENB_FB r0 *1 0,0
Ccc_ENB_FB ENB FB 1.8557e-17
* device instance cc_ENB_NB r0 *1 0,0
Ccc_ENB_NB ENB NB 1.8557e-17
* device instance cc_ENB_PB r0 *1 0,0
Ccc_ENB_PB ENB PB 1.8557e-17
* device instance cc_ENB_SS r0 *1 0,0
Ccc_ENB_SS ENB SS 1.8557e-17
* device instance cc_ENB_TC_D1 r0 *1 0,0
Ccc_ENB_TC_D1 ENB TC_D1 6.509e-18
* device instance cc_ENB_TC_TAIL r0 *1 0,0
Ccc_ENB_TC_TAIL ENB TC_TAIL 1.9528e-17
* device instance cc_ENB_TS_CMP r0 *1 0,0
Ccc_ENB_TS_CMP ENB TS_CMP 1.3019e-17
* device instance cc_ENB_TS_MID r0 *1 0,0
Ccc_ENB_TS_MID ENB TS_MID 2.5066e-17
* device instance cc_ENB_TS_REF r0 *1 0,0
Ccc_ENB_TS_REF ENB TS_REF 3.0604e-17
* device instance cc_ENB_TS_SNS r0 *1 0,0
Ccc_ENB_TS_SNS ENB TS_SNS 3.0604e-17
* device instance cc_ENB_VIN r0 *1 0,0
Ccc_ENB_VIN ENB VIN 2.5066e-17
* device instance cc_ENB_VOUT r0 *1 0,0
Ccc_ENB_VOUT ENB VOUT 2.5066e-17
* device instance cc_ENB_VREF r0 *1 0,0
Ccc_ENB_VREF ENB VREF 1.2047e-17
* device instance cc_FB_NB r0 *1 0,0
Ccc_FB_NB FB NB 1.3019e-17
* device instance cc_FB_N_FBB r0 *1 0,0
Ccc_FB_N_FBB FB N_FBB 1.3019e-17
* device instance cc_FB_PB r0 *1 0,0
Ccc_FB_PB FB PB 1.3019e-17
* device instance cc_FB_SS r0 *1 0,0
Ccc_FB_SS FB SS 6.509e-18
* device instance cc_FB_TC_D1 r0 *1 0,0
Ccc_FB_TC_D1 FB TC_D1 6.509e-18
* device instance cc_FB_TC_TAIL r0 *1 0,0
Ccc_FB_TC_TAIL FB TC_TAIL 1.9528e-17
* device instance cc_FB_TS_CMP r0 *1 0,0
Ccc_FB_TS_CMP FB TS_CMP 1.3019e-17
* device instance cc_FB_TS_MID r0 *1 0,0
Ccc_FB_TS_MID FB TS_MID 2.5066e-17
* device instance cc_FB_TS_REF r0 *1 0,0
Ccc_FB_TS_REF FB TS_REF 3.0604e-17
* device instance cc_FB_TS_SNS r0 *1 0,0
Ccc_FB_TS_SNS FB TS_SNS 3.0604e-17
* device instance cc_FB_VIN r0 *1 0,0
Ccc_FB_VIN FB VIN 2.5066e-17
* device instance cc_FB_VOUT r0 *1 0,0
Ccc_FB_VOUT FB VOUT 2.5066e-17
* device instance cc_NB_N_FBB r0 *1 0,0
Ccc_NB_N_FBB NB N_FBB 1.3019e-17
* device instance cc_NB_PB r0 *1 0,0
Ccc_NB_PB NB PB 6.509e-18
* device instance cc_NB_SS r0 *1 0,0
Ccc_NB_SS NB SS 6.509e-18
* device instance cc_NB_TS_MID r0 *1 0,0
Ccc_NB_TS_MID NB TS_MID 2.5066e-17
* device instance cc_NB_TS_REF r0 *1 0,0
Ccc_NB_TS_REF NB TS_REF 1.8557e-17
* device instance cc_NB_TS_SNS r0 *1 0,0
Ccc_NB_TS_SNS NB TS_SNS 1.8557e-17
* device instance cc_NB_VIN r0 *1 0,0
Ccc_NB_VIN NB VIN 4.9161e-17
* device instance cc_NB_VOUT r0 *1 0,0
Ccc_NB_VOUT NB VOUT 6.509e-18
* device instance cc_N_FBB_VIN r0 *1 0,0
Ccc_N_FBB_VIN N_FBB VIN 1.3019e-17
* device instance cc_N_FBB_VOUT r0 *1 0,0
Ccc_N_FBB_VOUT N_FBB VOUT 1.3019e-17
* device instance cc_PB_SS r0 *1 0,0
Ccc_PB_SS PB SS 6.509e-18
* device instance cc_PB_TC_D1 r0 *1 0,0
Ccc_PB_TC_D1 PB TC_D1 6.509e-18
* device instance cc_PB_TC_TAIL r0 *1 0,0
Ccc_PB_TC_TAIL PB TC_TAIL 1.9528e-17
* device instance cc_PB_TS_CMP r0 *1 0,0
Ccc_PB_TS_CMP PB TS_CMP 1.3019e-17
* device instance cc_PB_TS_MID r0 *1 0,0
Ccc_PB_TS_MID PB TS_MID 2.5066e-17
* device instance cc_PB_TS_REF r0 *1 0,0
Ccc_PB_TS_REF PB TS_REF 3.0604e-17
* device instance cc_PB_TS_SNS r0 *1 0,0
Ccc_PB_TS_SNS PB TS_SNS 3.0604e-17
* device instance cc_PB_VIN r0 *1 0,0
Ccc_PB_VIN PB VIN 4.3623e-17
* device instance cc_PB_VOUT r0 *1 0,0
Ccc_PB_VOUT PB VOUT 4.3623e-17
* device instance cc_PB_VREF r0 *1 0,0
Ccc_PB_VREF PB VREF 1.2047e-17
* device instance cc_SS_TC_D1 r0 *1 0,0
Ccc_SS_TC_D1 SS TC_D1 6.509e-18
* device instance cc_SS_TC_TAIL r0 *1 0,0
Ccc_SS_TC_TAIL SS TC_TAIL 1.9528e-17
* device instance cc_SS_TS_CMP r0 *1 0,0
Ccc_SS_TS_CMP SS TS_CMP 1.3019e-17
* device instance cc_SS_TS_MID r0 *1 0,0
Ccc_SS_TS_MID SS TS_MID 2.5066e-17
* device instance cc_SS_TS_REF r0 *1 0,0
Ccc_SS_TS_REF SS TS_REF 3.0604e-17
* device instance cc_SS_TS_SNS r0 *1 0,0
Ccc_SS_TS_SNS SS TS_SNS 3.0604e-17
* device instance cc_SS_VIN r0 *1 0,0
Ccc_SS_VIN SS VIN 2.5066e-17
* device instance cc_SS_VOUT r0 *1 0,0
Ccc_SS_VOUT SS VOUT 2.5066e-17
* device instance cc_SS_VREF r0 *1 0,0
Ccc_SS_VREF SS VREF 1.2047e-17
* device instance cc_TC_D1_TC_TAIL r0 *1 0,0
Ccc_TC_D1_TC_TAIL TC_D1 TC_TAIL 6.509e-18
* device instance cc_TC_D1_TS_CMP r0 *1 0,0
Ccc_TC_D1_TS_CMP TC_D1 TS_CMP 1.3019e-17
* device instance cc_TC_D1_TS_REF r0 *1 0,0
Ccc_TC_D1_TS_REF TC_D1 TS_REF 3.7114e-17
* device instance cc_TC_D1_TS_SNS r0 *1 0,0
Ccc_TC_D1_TS_SNS TC_D1 TS_SNS 6.509e-18
* device instance cc_TC_D1_VIN r0 *1 0,0
Ccc_TC_D1_VIN TC_D1 VIN 3.7114e-17
* device instance cc_TC_D1_VOUT r0 *1 0,0
Ccc_TC_D1_VOUT TC_D1 VOUT 3.7114e-17
* device instance cc_TC_D1_VREF r0 *1 0,0
Ccc_TC_D1_VREF TC_D1 VREF 1.2047e-17
* device instance cc_TC_TAIL_TS_REF r0 *1 0,0
Ccc_TC_TAIL_TS_REF TC_TAIL TS_REF 1.9528e-17
* device instance cc_TC_TAIL_TS_SNS r0 *1 0,0
Ccc_TC_TAIL_TS_SNS TC_TAIL TS_SNS 1.9528e-17
* device instance cc_TC_TAIL_VIN r0 *1 0,0
Ccc_TC_TAIL_VIN TC_TAIL VIN 1.9528e-17
* device instance cc_TC_TAIL_VOUT r0 *1 0,0
Ccc_TC_TAIL_VOUT TC_TAIL VOUT 1.9528e-17
* device instance cc_TS_CMP_TS_HYS r0 *1 0,0
Ccc_TS_CMP_TS_HYS TS_CMP TS_HYS 1.3019e-17
* device instance cc_TS_CMP_TS_REF r0 *1 0,0
Ccc_TS_CMP_TS_REF TS_CMP TS_REF 4.3623e-17
* device instance cc_TS_CMP_TS_SNS r0 *1 0,0
Ccc_TS_CMP_TS_SNS TS_CMP TS_SNS 1.3019e-17
* device instance cc_TS_CMP_VIN r0 *1 0,0
Ccc_TS_CMP_VIN TS_CMP VIN 4.3623e-17
* device instance cc_TS_CMP_VOUT r0 *1 0,0
Ccc_TS_CMP_VOUT TS_CMP VOUT 4.3623e-17
* device instance cc_TS_CMP_VREF r0 *1 0,0
Ccc_TS_CMP_VREF TS_CMP VREF 1.2047e-17
* device instance cc_TS_HYS_TS_REF r0 *1 0,0
Ccc_TS_HYS_TS_REF TS_HYS TS_REF 1.3019e-17
* device instance cc_TS_HYS_VIN r0 *1 0,0
Ccc_TS_HYS_VIN TS_HYS VIN 1.3019e-17
* device instance cc_TS_HYS_VOUT r0 *1 0,0
Ccc_TS_HYS_VOUT TS_HYS VOUT 1.3019e-17
* device instance cc_TS_MID_TS_SNS r0 *1 0,0
Ccc_TS_MID_TS_SNS TS_MID TS_SNS 1.8557e-17
* device instance cc_TS_MID_VIN r0 *1 0,0
Ccc_TS_MID_VIN TS_MID VIN 2.5066e-17
* device instance cc_TS_MID_VOUT r0 *1 0,0
Ccc_TS_MID_VOUT TS_MID VOUT 2.5066e-17
* device instance cc_TS_REF_TS_SNS r0 *1 0,0
Ccc_TS_REF_TS_SNS TS_REF TS_SNS 3.0604e-17
* device instance cc_TS_REF_VIN r0 *1 0,0
Ccc_TS_REF_VIN TS_REF VIN 4.3623e-17
* device instance cc_TS_REF_VOUT r0 *1 0,0
Ccc_TS_REF_VOUT TS_REF VOUT 4.3623e-17
* device instance cc_TS_REF_VREF r0 *1 0,0
Ccc_TS_REF_VREF TS_REF VREF 1.2047e-17
* device instance cc_TS_SNS_VIN r0 *1 0,0
Ccc_TS_SNS_VIN TS_SNS VIN 3.7114e-17
* device instance cc_TS_SNS_VOUT r0 *1 0,0
Ccc_TS_SNS_VOUT TS_SNS VOUT 3.7114e-17
* device instance cc_TS_SNS_VREF r0 *1 0,0
Ccc_TS_SNS_VREF TS_SNS VREF 1.2047e-17
* device instance cc_VIN_VOUT r0 *1 0,0
Ccc_VIN_VOUT VIN VOUT 3.2547e-16
* device instance cc_VIN_VREF r0 *1 0,0
Ccc_VIN_VREF VIN VREF 1.2047e-17
* device instance cc_VOUT_VREF r0 *1 0,0
Ccc_VOUT_VREF VOUT VREF 1.2047e-17
* device instance vsubs_dctie r0 *1 0,0
Rvsubs_dctie vsubs 0 1e+12
.ENDS ldo_core
