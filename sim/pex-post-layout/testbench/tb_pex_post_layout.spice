* klt pex testbench for the LDO core post-layout verification (issue #20).
* Regenerated by sim/pex-post-layout/bin/gen-pex-testbench.py -- do not
* hand-edit.
*
* `.include`s the schematic-equivalent DUT (ldo_core_schematic_dut.spice,
* same file); `klt pex` re-points this one line at its own freshly
* `--parasitics --pdk sky130A`-extracted netlist for the extracted-side
* leg, reusing every source/analysis/measurement below byte-identically on
* both legs. No `.model`/`.lib` line is needed here -- the klt-sim request's
* own `corners.process` + `models.lib` fields resolve sky130's combined
* `.lib` (which both this file's `sky130_fd_pr__*_g5v0d10v5` devices and the
* extracted side's PDK-bound X-cards read from) per-corner. See
* sim/pex-post-layout/README.md's "models.lib" note for why the request
* uses `models.lib` alone rather than pairing it with `models.pdk`.
*
* Runs `klt pex` with `--pdk sky130A` (unlike a from-scratch pex testbench
* might default to): the bare, non-PDK `klt extract` device-class output
* (`nfet`/`pfet`/`res_high_po`/`res_xhigh_po`) is NOT directly
* ngspice-simulatable for this layout -- sky130's `res_high_po`/
* `res_xhigh_po` drawn-resistor classes always carry a 3rd (bulk/tap)
* terminal (`R$n a b 0 <value> res_high_po`), which ngspice's native 2-node
* `R` element rejects outright ("unknown parameter (res_high_po)") --
* confirmed by direct trial, not assumed; not already tracked upstream as
* of 2026-08-18 (see sim/pex-post-layout/README.md). `--pdk` sidesteps it
* by writing every device (MOS and resistor alike) as a real PDK `X`
* subcircuit call, which supports arbitrary pin counts.
*
* `--pdk`'s own disclosed cost: `klt extract --pdk`'s MOS model-binding
* table is hardcoded to sky130's 01v8 core-device flavor
* (src/klayout_tools/pdk_models.py), while this design's schematic (this
* DUT file, above) uses the 5V-tolerant g5v0d10v5 flavor throughout -- a
* real, already-tracked upstream gap (klayout-tools#1089, open as of
* 2026-08-18). The extracted-side leg's MOS devices are therefore
* systematically the wrong flavor; every delta[] row this experiment
* records conflates that model-substitution error with genuine post-layout
* parasitics and MUST NOT be read as a clean parasitics-only fidelity
* measurement or as spec-compliance evidence. See
* sim/pex-post-layout/README.md for the full caveat.
.include "ldo_core_schematic_dut.spice"

.param vvin=3.3
.param iload=1m

Vvin   VIN   0 DC {vvin}
Ven    EN    0 DC {vvin}
Vvref  VREF  0 DC 1.2
Cout   VOUT  VESR 1u
Resr   VESR  0    10m
Iload  VOUT  0    DC {iload}

Xldo 0 AMP_ENN BIASP BIAS_ENN CL_CMP CL_SNS EA_CZ EA_D1 EA_D2 EA_OUT EA_TAIL EN ENB FB NB N_FBB PB SS TC_D1 TC_TAIL TS_CMP TS_HYS TS_MID TS_REF TS_SNS VIN VOUT VREF ldo_core
