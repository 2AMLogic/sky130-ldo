* klt pex testbench for the LDO core post-layout verification (issue #20).
* Regenerated by sim/pex-post-layout/bin/gen-pex-testbench.py -- do not
* hand-edit.
*
* `.include`s the schematic-equivalent DUT (ldo_core_schematic_dut.spice,
* same file); `klt pex` re-points this one line at its own freshly
* `--parasitics --pdk sky130A`-extracted netlist for the extracted-side
* leg, reusing every source/analysis/measurement below byte-identically on
* both legs. No `.model`/`.lib` line is needed here -- the klt-sim request's
* own `corners.process` + `models.lib` fields resolve sky130's combined
* `.lib` (which both this file's `sky130_fd_pr__*_g5v0d10v5` devices and the
* extracted side's PDK-bound X-cards read from) per-corner. See
* sim/pex-post-layout/README.md's "models.lib" note for why the request
* uses the PDK-relative `models` form (portable to the batch fleet).
*
* Runs `klt pex` with `--pdk sky130A` so MOS and 3-terminal sky130 resistors
* emit as PDK-bound `X` subcircuit calls (ngspice's 2-node `R` rejects bare
* 3-terminal resistor cards). For model binding and limitations, see the run
* record under sim/pex-post-layout/records/ and sim/pex-post-layout/README.md.
.include "ldo_core_schematic_dut.spice"

.param vvin=3.3
.param iload=1m

Vvin   VIN   0 DC {vvin}
Ven    EN    0 DC {vvin}
Vvref  VREF  0 DC 1.2
Cout   VOUT  VESR 1u
Resr   VESR  0    10m
Iload  VOUT  0    DC {iload}

Xldo 0 AMP_ENN BIASP BIAS_ENN CL_CMP CL_SNS EA_CZ EA_D1 EA_D2 EA_OUT EA_TAIL EN ENB FB NB N_FBB PB RC_A RC_B RC_TAIL SS TS_CMP TS_MID TS_REF TS_SNS VIN VOUT VREF ldo_core
