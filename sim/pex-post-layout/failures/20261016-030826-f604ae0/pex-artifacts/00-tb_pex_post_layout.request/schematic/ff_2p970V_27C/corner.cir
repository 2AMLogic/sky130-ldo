* klt sim -- generated corner deck, do not edit
.lib /opt/pdk/sky130A/libs.tech/combined/sky130.lib.spice ff
.include /var/tmp/eda-job-klt-sim-9aec907401d4/inputs/netlist.cir
.temp 27
.meas dc vout_light_load_v FIND V(VOUT) AT=1m
.meas dc vout_full_load_v FIND V(VOUT) AT=50m
.meas dc vin_minus_vout_full_load_v FIND PAR('V(VIN)-V(VOUT)') AT=50m
.control
save all
alter vvin=2.97
dc Iload 1m 50m 49m
quit
.endc
.end
