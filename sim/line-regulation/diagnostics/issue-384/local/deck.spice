* line-regulation corner deck -- generated by sim/bin/corner-run.py, do not edit
* corner: tt_27c_3.30v
.param vsup=3.3
.option wnflag=1
.temp 27
.lib "/home/ubuntu/.volare/sky130A/libs.tech/combined/sky130.lib.spice" tt
** sch_path: sim/line-regulation/testbench/tb_line_regulation.sch
**.subckt tb_line_regulation
VVIN VIN 0 3.3
.save i(vvin)
VEN EN 0 dc 0 pwl(0 0 100u 0 101u 3.3 10 3.3)
.save i(ven)
VVREF VREF 0 1.2
.save i(vvref)
xldo VOUT VREF EN VIN ldo_3v3in_1v8out
COUT VOUT VESR 1u m=1
RESR VESR 0 10m m=1
ILOAD VOUT 0 1m
**.ends

* expanding   symbol:  design/ldo_3v3in_1v8out.sym # of pins=4
** sym_path: design/ldo_3v3in_1v8out.sym
** sch_path: design/ldo_3v3in_1v8out.sch
.subckt ldo_3v3in_1v8out VOUT VREF EN VIN
*.ipin VIN
*.ipin EN
*.ipin VREF
*.opin VOUT
XR_BIAS VIN NB 0 sky130_fd_pr__res_high_po W=0.42 L=1500 mult=1 m=1
XM_BIASN1 NB NB BIAS_ENN 0 sky130_fd_pr__nfet_g5v0d10v5 L=1 W=4 nf=1 ad=1.16
+ as=1.16 pd=8.58 ps=8.58
+ nrd=0.0725 nrs=0.0725 sa=0 sb=0 sd=0 mult=1 m=1
XM_ENN BIAS_ENN EN 0 0 sky130_fd_pr__nfet_g5v0d10v5 L=0.5 W=10 nf=1 ad=2.9
+ as=2.9 pd=20.58 ps=20.58
+ nrd=0.029 nrs=0.029 sa=0 sb=0 sd=0 mult=1 m=1
XM_BIASN2 BIASP NB BIAS_ENN 0 sky130_fd_pr__nfet_g5v0d10v5 L=1 W=4 nf=1 ad=1.16
+ as=1.16 pd=8.58 ps=8.58
+ nrd=0.0725 nrs=0.0725 sa=0 sb=0 sd=0 mult=1 m=1
XM_BIASP1 BIASP BIASP VIN VIN sky130_fd_pr__pfet_g5v0d10v5 L=1 W=10 nf=2 ad=1.45
+ as=2.9 pd=10.58 ps=21.16
+ nrd=0.029 nrs=0.029 sa=0 sb=0 sd=0 mult=1 m=1
XM_ENP2 BIASP EN VIN VIN sky130_fd_pr__pfet_g5v0d10v5 L=0.5 W=10 nf=1 ad=2.9
+ as=2.9 pd=20.58 ps=20.58
+ nrd=0.029 nrs=0.029 sa=0 sb=0 sd=0 mult=1 m=1
XM_TAIL EA_TAIL BIASP VIN VIN sky130_fd_pr__pfet_g5v0d10v5 L=2 W=40 nf=8 ad=5.8
+ as=7.25 pd=42.32 ps=52.9
+ nrd=0.00725 nrs=0.00725 sa=0 sb=0 sd=0 mult=1 m=1
XM_IN1 EA_D1 FB EA_TAIL VIN sky130_fd_pr__pfet_g5v0d10v5 L=2 W=10 nf=2 ad=1.45
+ as=2.9 pd=10.58 ps=21.16
+ nrd=0.029 nrs=0.029 sa=0 sb=0 sd=0 mult=1 m=1
XM_IN2 EA_D2 VREF EA_TAIL VIN sky130_fd_pr__pfet_g5v0d10v5 L=2 W=10 nf=2 ad=1.45
+ as=2.9 pd=10.58 ps=21.16
+ nrd=0.029 nrs=0.029 sa=0 sb=0 sd=0 mult=1 m=1
XM_MIR1 EA_D1 EA_D1 AMP_ENN 0 sky130_fd_pr__nfet_g5v0d10v5 L=4 W=10 nf=2 ad=1.45
+ as=2.9 pd=10.58 ps=21.16
+ nrd=0.029 nrs=0.029 sa=0 sb=0 sd=0 mult=1 m=1
XM_MIR2 EA_OUT EA_D1 AMP_ENN 0 sky130_fd_pr__nfet_g5v0d10v5 L=4 W=10 nf=2 ad=1.45
+ as=2.9 pd=10.58 ps=21.16
+ nrd=0.029 nrs=0.029 sa=0 sb=0 sd=0 mult=1 m=1
XM_ENN2 AMP_ENN EN 0 0 sky130_fd_pr__nfet_g5v0d10v5 L=0.5 W=10 nf=1 ad=2.9
+ as=2.9 pd=20.58 ps=20.58
+ nrd=0.029 nrs=0.029 sa=0 sb=0 sd=0 mult=1 m=1
XM_ENP EA_OUT EN VIN VIN sky130_fd_pr__pfet_g5v0d10v5 L=0.5 W=10 nf=1 ad=2.9
+ as=2.9 pd=20.58 ps=20.58
+ nrd=0.029 nrs=0.029 sa=0 sb=0 sd=0 mult=1 m=1
XM_MIR3 EA_D2 EA_D2 AMP_ENN 0 sky130_fd_pr__nfet_g5v0d10v5 L=4 W=10 nf=2 ad=1.45
+ as=2.9 pd=10.58 ps=21.16
+ nrd=0.029 nrs=0.029 sa=0 sb=0 sd=0 mult=1 m=1
XM_MIR4 PB EA_D2 AMP_ENN 0 sky130_fd_pr__nfet_g5v0d10v5 L=4 W=10 nf=2 ad=1.45
+ as=2.9 pd=10.58 ps=21.16
+ nrd=0.029 nrs=0.029 sa=0 sb=0 sd=0 mult=1 m=1
XM_MIRP1 PB PB VIN VIN sky130_fd_pr__pfet_g5v0d10v5 L=4 W=20 nf=4 ad=2.9
+ as=4.35 pd=21.16 ps=31.74
+ nrd=0.0145 nrs=0.0145 sa=0 sb=0 sd=0 mult=1 m=1
XM_MIRP2 EA_OUT PB VIN VIN sky130_fd_pr__pfet_g5v0d10v5 L=4 W=20 nf=4 ad=2.9
+ as=4.35 pd=21.16 ps=31.74
+ nrd=0.0145 nrs=0.0145 sa=0 sb=0 sd=0 mult=1 m=1
XM_ENP5 PB EN VIN VIN sky130_fd_pr__pfet_g5v0d10v5 L=0.5 W=2 nf=1 ad=0.58
+ as=0.58 pd=4.58 ps=4.58
+ nrd=0.145 nrs=0.145 sa=0 sb=0 sd=0 mult=1 m=1
XM_PASS VOUT EA_OUT VIN VIN sky130_fd_pr__pfet_g5v0d10v5 L=0.5 W=100 nf=25 ad=15.08
+ as=15.08 pd=111.54 ps=111.54
+ nrd=0.0029 nrs=0.0029 sa=0 sb=0 sd=0 mult=50 m=50
C_COMP VOUT EA_CZ 150p m=1
XR_CZ EA_CZ EA_OUT 0 sky130_fd_pr__res_xhigh_po W=0.42 L=52 mult=1 m=1
XR_FB_A VOUT FB 0 sky130_fd_pr__res_xhigh_po W=0.42 L=180 mult=1 m=1
XR_FB_B FB N_FBB 0 sky130_fd_pr__res_xhigh_po W=0.42 L=180 mult=1 m=1
XR_FB_C N_FBB 0 0 sky130_fd_pr__res_xhigh_po W=0.42 L=180 mult=1 m=1
XM_SENSE CL_SNS EA_OUT VIN VIN sky130_fd_pr__pfet_g5v0d10v5 L=0.5 W=0.42 nf=1 ad=0.1218
+ as=0.1218 pd=1.42 ps=1.42
+ nrd=0.690476 nrs=0.690476 sa=0 sb=0 sd=0 mult=2 m=2
XM_CLN1 CL_SNS CL_SNS AMP_ENN 0 sky130_fd_pr__nfet_g5v0d10v5 L=1 W=20 nf=1 ad=5.8
+ as=5.8 pd=40.58 ps=40.58
+ nrd=0.0145 nrs=0.0145 sa=0 sb=0 sd=0 mult=1 m=1
XM_CLN2 CL_CMP CL_SNS AMP_ENN 0 sky130_fd_pr__nfet_g5v0d10v5 L=1 W=1.6 nf=1 ad=0.464
+ as=0.464 pd=3.78 ps=3.78
+ nrd=0.18125 nrs=0.18125 sa=0 sb=0 sd=0 mult=1 m=1
XM_CLP CL_CMP BIASP VIN VIN sky130_fd_pr__pfet_g5v0d10v5 L=1 W=10 nf=2 ad=1.45
+ as=2.9 pd=10.58 ps=21.16
+ nrd=0.029 nrs=0.029 sa=0 sb=0 sd=0 mult=1 m=1
XM_CLIM EA_OUT CL_CMP VIN VIN sky130_fd_pr__pfet_g5v0d10v5 L=0.5 W=20 nf=4 ad=2.9
+ as=4.35 pd=21.16 ps=31.74
+ nrd=0.0145 nrs=0.0145 sa=0 sb=0 sd=0 mult=1 m=1
XM_ENP3 CL_CMP EN VIN VIN sky130_fd_pr__pfet_g5v0d10v5 L=0.5 W=2 nf=1 ad=0.58
+ as=0.58 pd=4.58 ps=4.58
+ nrd=0.145 nrs=0.145 sa=0 sb=0 sd=0 mult=1 m=1
C_CL VIN CL_CMP 1p m=1
XM_INVP ENB EN VIN VIN sky130_fd_pr__pfet_g5v0d10v5 L=0.5 W=2 nf=1 ad=0.58
+ as=0.58 pd=4.58 ps=4.58
+ nrd=0.145 nrs=0.145 sa=0 sb=0 sd=0 mult=1 m=1
XM_INVN ENB EN 0 0 sky130_fd_pr__nfet_g5v0d10v5 L=0.5 W=1 nf=1 ad=0.29
+ as=0.29 pd=2.58 ps=2.58
+ nrd=0.29 nrs=0.29 sa=0 sb=0 sd=0 mult=1 m=1
XM_SSDIS SS ENB 0 0 sky130_fd_pr__nfet_g5v0d10v5 L=0.5 W=2 nf=1 ad=0.58
+ as=0.58 pd=4.58 ps=4.58
+ nrd=0.145 nrs=0.145 sa=0 sb=0 sd=0 mult=1 m=1
XM_SSCHG SS BIASP VIN VIN sky130_fd_pr__pfet_g5v0d10v5 L=8 W=1 nf=1 ad=0.29
+ as=0.29 pd=2.58 ps=2.58
+ nrd=0.29 nrs=0.29 sa=0 sb=0 sd=0 mult=1 m=1
C_SS SS 0 10p m=1
XM_IN2S EA_D2 SS EA_TAIL VIN sky130_fd_pr__pfet_g5v0d10v5 L=2 W=10 nf=2 ad=1.45
+ as=2.9 pd=10.58 ps=21.16
+ nrd=0.029 nrs=0.029 sa=0 sb=0 sd=0 mult=1 m=1
XM_TSPS TS_SNS BIASP VIN VIN sky130_fd_pr__pfet_g5v0d10v5 L=1 W=1.25 nf=1 ad=0.3625
+ as=0.3625 pd=3.08 ps=3.08
+ nrd=0.232 nrs=0.232 sa=0 sb=0 sd=0 mult=1 m=1
XM_TSD1 TS_SNS TS_SNS TS_MID 0 sky130_fd_pr__nfet_g5v0d10v5 L=4 W=80 nf=16 ad=11.6
+ as=13.05 pd=84.64 ps=95.22
+ nrd=0.003625 nrs=0.003625 sa=0 sb=0 sd=0 mult=1 m=1
XM_TSD2 TS_MID TS_MID AMP_ENN 0 sky130_fd_pr__nfet_g5v0d10v5 L=4 W=80 nf=16 ad=11.6
+ as=13.05 pd=84.64 ps=95.22
+ nrd=0.003625 nrs=0.003625 sa=0 sb=0 sd=0 mult=1 m=1
XM_TSPR TS_REF BIASP VIN VIN sky130_fd_pr__pfet_g5v0d10v5 L=1 W=7 nf=1 ad=2.03
+ as=2.03 pd=14.58 ps=14.58
+ nrd=0.0414286 nrs=0.0414286 sa=0 sb=0 sd=0 mult=1 m=1
XM_TSR1 TS_REF TS_REF AMP_ENN 0 sky130_fd_pr__nfet_g5v0d10v5 L=2 W=0.42 nf=1 ad=0.1218
+ as=0.1218 pd=1.42 ps=1.42
+ nrd=0.690476 nrs=0.690476 sa=0 sb=0 sd=0 mult=1 m=1
XM_TSHUT EA_OUT TS_CMP VIN VIN sky130_fd_pr__pfet_g5v0d10v5 L=0.5 W=20 nf=4 ad=2.9
+ as=4.35 pd=21.16 ps=31.74
+ nrd=0.0145 nrs=0.0145 sa=0 sb=0 sd=0 mult=1 m=1
XM_ENP4 TS_CMP EN VIN VIN sky130_fd_pr__pfet_g5v0d10v5 L=0.5 W=2 nf=1 ad=0.58
+ as=0.58 pd=4.58 ps=4.58
+ nrd=0.145 nrs=0.145 sa=0 sb=0 sd=0 mult=1 m=1
C_TS VIN TS_CMP 1p m=1
XM_RCTAIL RC_TAIL NB AMP_ENN 0 sky130_fd_pr__nfet_g5v0d10v5 L=1 W=1 nf=1 ad=0.29
+ as=0.29 pd=2.58 ps=2.58
+ nrd=0.29 nrs=0.29 sa=0 sb=0 sd=0 mult=1 m=1
XM_RCN1 RC_A TS_SNS RC_TAIL 0 sky130_fd_pr__nfet_g5v0d10v5 L=2 W=10 nf=2 ad=1.45
+ as=2.9 pd=10.58 ps=21.16
+ nrd=0.029 nrs=0.029 sa=0 sb=0 sd=0 mult=1 m=1
XM_RCN2 RC_B TS_REF RC_TAIL 0 sky130_fd_pr__nfet_g5v0d10v5 L=2 W=10 nf=2 ad=1.45
+ as=2.9 pd=10.58 ps=21.16
+ nrd=0.029 nrs=0.029 sa=0 sb=0 sd=0 mult=1 m=1
XM_RCD1 RC_A RC_A VIN VIN sky130_fd_pr__pfet_g5v0d10v5 L=2 W=10 nf=2 ad=1.45
+ as=2.9 pd=10.58 ps=21.16
+ nrd=0.029 nrs=0.029 sa=0 sb=0 sd=0 mult=1 m=1
XM_RCD2 RC_B RC_B VIN VIN sky130_fd_pr__pfet_g5v0d10v5 L=2 W=10 nf=2 ad=1.45
+ as=2.9 pd=10.58 ps=21.16
+ nrd=0.029 nrs=0.029 sa=0 sb=0 sd=0 mult=1 m=1
XM_RCC1 RC_A RC_B VIN VIN sky130_fd_pr__pfet_g5v0d10v5 L=2 W=17 nf=2 ad=2.465
+ as=4.93 pd=17.58 ps=35.16
+ nrd=0.0170588 nrs=0.0170588 sa=0 sb=0 sd=0 mult=1 m=1
XM_RCC2 RC_B RC_A VIN VIN sky130_fd_pr__pfet_g5v0d10v5 L=2 W=17 nf=2 ad=2.465
+ as=4.93 pd=17.58 ps=35.16
+ nrd=0.0170588 nrs=0.0170588 sa=0 sb=0 sd=0 mult=1 m=1
XM_RCEA RC_A EN VIN VIN sky130_fd_pr__pfet_g5v0d10v5 L=0.5 W=2 nf=1 ad=0.58
+ as=0.58 pd=4.58 ps=4.58
+ nrd=0.145 nrs=0.145 sa=0 sb=0 sd=0 mult=1 m=1
XM_RCEB RC_B EN VIN VIN sky130_fd_pr__pfet_g5v0d10v5 L=0.5 W=2 nf=1 ad=0.58
+ as=0.58 pd=4.58 ps=4.58
+ nrd=0.145 nrs=0.145 sa=0 sb=0 sd=0 mult=1 m=1
XM_RCOP TS_CMP RC_A VIN VIN sky130_fd_pr__pfet_g5v0d10v5 L=1 W=2 nf=1 ad=0.58
+ as=0.58 pd=4.58 ps=4.58
+ nrd=0.145 nrs=0.145 sa=0 sb=0 sd=0 mult=1 m=1
XM_RCOS TS_CMP NB AMP_ENN 0 sky130_fd_pr__nfet_g5v0d10v5 L=2 W=0.5 nf=1 ad=0.145
+ as=0.145 pd=1.58 ps=1.58
+ nrd=0.58 nrs=0.58 sa=0 sb=0 sd=0 mult=1 m=1
XM_RCEO TS_CMP EN VIN VIN sky130_fd_pr__pfet_g5v0d10v5 L=0.5 W=2 nf=1 ad=0.58
+ as=0.58 pd=4.58 ps=4.58
+ nrd=0.145 nrs=0.145 sa=0 sb=0 sd=0 mult=1 m=1
.ends

.control
save all
* Each point is a COLD-START, SETTLED transient, not a bare
* unconstrained .op (issue #172, contract #171): `uic` starts every node
* at its natural cold value with EN low (the testbench's VEN steps high
* at 101us), so the block powers up through its own soft-start ramp and
* no operating-point solve happens at all. v(vout) is averaged over the
* settled 199ms-200ms tail. See the testbench header for why a seeded
* `op` cannot deliver this, and sim/load-regulation for why the window
* is this long (that bench's 0mA point needs it; these four do not, but
* both benches carry one convention).
* EN convention (issue #196): EN's high level is the INSTANTANEOUS VIN,
* not the corner runner's 'vsup' label. On this bench those are
* different quantities -- VVIN is the bench's own source, 'alter'ed
* between 2.97V and 3.63V INSIDE every corner, while 'vsup' is fixed per
* corner -- so the old convention put EN 0.66V BELOW VIN at the
* VIN=3.63V point of every *_2.97v corner. That is #187's EN-below-VIN
* geometry (five PMOS shutdown clamps whose sources are VIN; gate drive
* is VIN-EN), and it leaves no solver diagnostic. Each point below
* therefore sets ONE literal (`vinpt`) and points BOTH VVIN and VEN's
* pwl high level at it, so the two cannot drift apart in a later edit.
* design/README.md -> 'Enable/shutdown' specifies EN as 'active-high,
* full-rail (0V / VIN)', so this restores the documented interface at
* every measured point; no spec or schematic line moves.
* Tail envelope (issue #377): each endpoint also measures min/max of
* v(vout) over the SAME settled 199ms-200ms tail as its average, in the
* same tranN plot, graded against the Output window (sampled extrema).
* --- point 1: VIN=2.97V, I_LOAD=1mA (deck default) ---
set vinpt = 2.97
alter vvin = $vinpt
alter @ven[pwl] = [ 0 0 100u 0 101u $vinpt 10 $vinpt ]
tran 10u 200m uic
meas tran vout_1ma_lo avg v(vout) from=199m to=200m
meas tran vout_1ma_lo_min min v(vout) from=199m to=200m
meas tran vout_1ma_lo_max max v(vout) from=199m to=200m
* --- point 2: VIN=3.63V, I_LOAD=1mA ---
set vinpt = 3.63
alter vvin = $vinpt
alter @ven[pwl] = [ 0 0 100u 0 101u $vinpt 10 $vinpt ]
tran 10u 200m uic
meas tran vout_1ma_hi avg v(vout) from=199m to=200m
meas tran vout_1ma_hi_min min v(vout) from=199m to=200m
meas tran vout_1ma_hi_max max v(vout) from=199m to=200m
* --- point 3: VIN=2.97V, I_LOAD=50mA (altered) ---
alter iload = 50m
set vinpt = 2.97
alter vvin = $vinpt
alter @ven[pwl] = [ 0 0 100u 0 101u $vinpt 10 $vinpt ]
tran 10u 200m uic
meas tran vout_50ma_lo avg v(vout) from=199m to=200m
meas tran vout_50ma_lo_min min v(vout) from=199m to=200m
meas tran vout_50ma_lo_max max v(vout) from=199m to=200m
* --- point 4: VIN=3.63V, I_LOAD=50mA ---
set vinpt = 3.63
alter vvin = $vinpt
alter @ven[pwl] = [ 0 0 100u 0 101u $vinpt 10 $vinpt ]
tran 10u 200m uic
meas tran vout_50ma_hi avg v(vout) from=199m to=200m
meas tran vout_50ma_hi_min min v(vout) from=199m to=200m
meas tran vout_50ma_hi_max max v(vout) from=199m to=200m
let meas_line_reg_1ma_mv_per_v = abs(1000*(tran2.vout_1ma_hi - tran1.vout_1ma_lo)/(3.63-2.97))
let meas_line_reg_50ma_mv_per_v = abs(1000*(tran4.vout_50ma_hi - tran3.vout_50ma_lo)/(3.63-2.97))
let meas_vout_1ma_lo = tran1.vout_1ma_lo
let meas_vout_1ma_lo_min = tran1.vout_1ma_lo_min
let meas_vout_1ma_lo_max = tran1.vout_1ma_lo_max
let meas_vout_1ma_hi = tran2.vout_1ma_hi
let meas_vout_1ma_hi_min = tran2.vout_1ma_hi_min
let meas_vout_1ma_hi_max = tran2.vout_1ma_hi_max
let meas_vout_50ma_lo = tran3.vout_50ma_lo
let meas_vout_50ma_lo_min = tran3.vout_50ma_lo_min
let meas_vout_50ma_lo_max = tran3.vout_50ma_lo_max
let meas_vout_50ma_hi = tran4.vout_50ma_hi
let meas_vout_50ma_hi_min = tran4.vout_50ma_hi_min
let meas_vout_50ma_hi_max = tran4.vout_50ma_hi_max
print meas_line_reg_1ma_mv_per_v
print meas_line_reg_50ma_mv_per_v
print meas_vout_1ma_lo
print meas_vout_1ma_lo_min
print meas_vout_1ma_lo_max
print meas_vout_1ma_hi
print meas_vout_1ma_hi_min
print meas_vout_1ma_hi_max
print meas_vout_50ma_lo
print meas_vout_50ma_lo_min
print meas_vout_50ma_lo_max
print meas_vout_50ma_hi
print meas_vout_50ma_hi_min
print meas_vout_50ma_hi_max
quit
.endc
.end
