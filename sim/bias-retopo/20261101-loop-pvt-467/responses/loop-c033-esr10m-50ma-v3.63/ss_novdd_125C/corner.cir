* klt sim -- generated corner deck, do not edit
.lib /opt/pdk/sky130A/libs.tech/combined/sky130.lib.spice ss
.include /var/tmp/eda-job-klt-sim-f45e36c1eb4f/inputs/netlist.cir
.temp 125.0
.control
save all
set filetype=ascii
ac dec 30 1e-2 1e9
let __klt_xfer_0_num = v(xldo.fb)
let __klt_xfer_0_den = v(xldo.lg_den)
write /var/tmp/eda-job-klt-sim-f45e36c1eb4f/outputs/artifacts/ss_novdd_125C/transfer_0.raw __klt_xfer_0_num __klt_xfer_0_den
quit
.endc
.end
