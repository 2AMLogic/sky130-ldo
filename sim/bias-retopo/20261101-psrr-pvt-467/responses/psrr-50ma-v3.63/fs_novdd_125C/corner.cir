* klt sim -- generated corner deck, do not edit
.lib /opt/pdk/sky130A/libs.tech/combined/sky130.lib.spice fs
.include /var/tmp/eda-job-klt-sim-1b2d285e42f9/inputs/netlist.cir
.temp 125.0
.meas ac p1k find vdb(vout) at=1000
.meas ac p100k find vdb(vout) at=100000
.control
save all
ac lin 3 1e3 1e5
quit
.endc
.end
