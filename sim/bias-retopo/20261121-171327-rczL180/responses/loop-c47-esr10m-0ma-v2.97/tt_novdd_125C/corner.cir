* klt sim -- generated corner deck, do not edit
.lib /opt/pdk/sky130A/libs.tech/combined/sky130.lib.spice tt
.include /var/tmp/eda-job-klt-sim-05f9f3a0b72a/inputs/netlist.cir
.temp 125.0
.control
save all
set filetype=ascii
ac dec 30 1e-2 1e9
let __klt_xfer_0_num = v(xldo.fb)
let __klt_xfer_0_den = v(xldo.lg_den)
write /var/tmp/eda-job-klt-sim-05f9f3a0b72a/outputs/artifacts/tt_novdd_125C/transfer_0.raw __klt_xfer_0_num __klt_xfer_0_den
quit
.endc
.end
