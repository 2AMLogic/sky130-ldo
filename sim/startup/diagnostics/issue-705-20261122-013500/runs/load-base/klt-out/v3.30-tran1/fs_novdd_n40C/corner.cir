* klt sim -- generated corner deck, do not edit
.lib /opt/pdk/sky130A/libs.tech/combined/sky130.lib.spice fs
.include /var/tmp/eda-job-klt-sim-938a36a08ee4/inputs/netlist.cir
.temp -40.0
.control
save all
setplot new
echo klt_step_begin 0 $curplot
tran 10u 200m uic
echo klt_step_end 0 $curplot
set klt_plot_0 = $curplot
meas tran vout_0ma avg v(vout) from=199m to=200m
let tran1__vout_0ma = vout_0ma
print tran1__vout_0ma
meas tran vout_0ma_min min v(vout) from=199m to=200m
let tran1__vout_0ma_min = vout_0ma_min
print tran1__vout_0ma_min
meas tran vout_0ma_max max v(vout) from=199m to=200m
let tran1__vout_0ma_max = vout_0ma_max
print tran1__vout_0ma_max
quit
.endc
.end
