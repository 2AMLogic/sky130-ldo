* klt sim -- generated corner deck, do not edit
.lib /opt/pdk/sky130A/libs.tech/combined/sky130.lib.spice ss
.include /var/tmp/eda-job-klt-sim-1c1f5ba343b0/inputs/netlist.cir
.temp -40.0
.control
save all
setplot new
echo klt_step_begin 0 $curplot
tran 10u 200m uic
echo klt_step_end 0 $curplot
set klt_plot_0 = $curplot
meas tran vout_1ma_hi avg v(vout) from=199m to=200m
let tran2__vout_1ma_hi = vout_1ma_hi
print tran2__vout_1ma_hi
meas tran vout_1ma_hi_min min v(vout) from=199m to=200m
let tran2__vout_1ma_hi_min = vout_1ma_hi_min
print tran2__vout_1ma_hi_min
meas tran vout_1ma_hi_max max v(vout) from=199m to=200m
let tran2__vout_1ma_hi_max = vout_1ma_hi_max
print tran2__vout_1ma_hi_max
quit
.endc
.end
