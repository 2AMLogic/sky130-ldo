* klt sim -- generated corner deck, do not edit
.lib /opt/pdk/sky130A/libs.tech/combined/sky130.lib.spice fs
.include /var/tmp/eda-job-klt-sim-4c0bc385675b/inputs/netlist.cir
.temp -40.0
.control
save all
setplot new
echo klt_step_begin 0 $curplot
tran 10u 200m uic
echo klt_step_end 0 $curplot
set klt_plot_0 = $curplot
meas tran vout_50ma_hi avg v(vout) from=199m to=200m
let tran4__vout_50ma_hi = vout_50ma_hi
print tran4__vout_50ma_hi
meas tran vout_50ma_hi_min min v(vout) from=199m to=200m
let tran4__vout_50ma_hi_min = vout_50ma_hi_min
print tran4__vout_50ma_hi_min
meas tran vout_50ma_hi_max max v(vout) from=199m to=200m
let tran4__vout_50ma_hi_max = vout_50ma_hi_max
print tran4__vout_50ma_hi_max
quit
.endc
.end
