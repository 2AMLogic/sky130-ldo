* klt sim -- generated corner deck, do not edit
.lib /opt/pdk/sky130A/libs.tech/combined/sky130.lib.spice sf
.include /var/tmp/eda-job-klt-sim-749a93f58498/inputs/netlist.cir
.temp -40.0
.control
save all
setplot new
echo klt_step_begin 0 $curplot
tran 10u 200m uic
echo klt_step_end 0 $curplot
set klt_plot_0 = $curplot
meas tran vout_1ma_lo avg v(vout) from=199m to=200m
let tran1__vout_1ma_lo = vout_1ma_lo
print tran1__vout_1ma_lo
meas tran vout_1ma_lo_min min v(vout) from=199m to=200m
let tran1__vout_1ma_lo_min = vout_1ma_lo_min
print tran1__vout_1ma_lo_min
meas tran vout_1ma_lo_max max v(vout) from=199m to=200m
let tran1__vout_1ma_lo_max = vout_1ma_lo_max
print tran1__vout_1ma_lo_max
quit
.endc
.end
