* dropout-vs-load corner deck -- generated by sim/bin/corner-run.py, do not edit
* corner: tt_27c_3.30v
.param vsup=3.3
.option wnflag=1
.temp 27
.lib "/home/ubuntu/.volare/sky130A/libs.tech/combined/sky130.lib.spice" tt
** sch_path: sim/dropout-vs-load/testbench/tb_dropout_vs_load.sch
**.subckt tb_dropout_vs_load
VVIN VIN 0 PWL(0 0 100u 'vsup' 6m 'vsup' 14m 'vsup-2.13')
.save i(vvin)
VEN EN 0 PULSE(0 'vsup' 100u 1u 1u 100 200)
.save i(ven)
VVREF VREF 0 1.2
VVINA VINA 0 3.3
.save i(vvref)
xldo VOUT VREF EN VIN VINA ldo_3v3in_1v8out
COUT VOUT VESR 1u m=1
RESR VESR 0 10m m=1
ILOAD VOUT 0 PWL(0 0 2.5m 0 2.6m 50m)
**.ends

* expanding   symbol:  design/ldo_3v3in_1v8out.sym # of pins=4
** sym_path: design/ldo_3v3in_1v8out.sym
** sch_path: design/ldo_3v3in_1v8out.sch
.subckt ldo_3v3in_1v8out VOUT VREF EN VIN VINA
*.ipin VIN
*.ipin EN
*.ipin VREF
*.opin VOUT
XR_BIAS VIN NB 0 sky130_fd_pr__res_high_po W=0.42 L=1500 mult=1 m=1
XM_BIASN1 NB NB BIAS_ENN 0 sky130_fd_pr__nfet_g5v0d10v5 L=1 W=4 nf=1 ad=1.16
+ as=1.16 pd=8.58 ps=8.58
+ nrd=0.0725 nrs=0.0725 sa=0 sb=0 sd=0 mult=1 m=1
XM_ENN BIAS_ENN EN 0 0 sky130_fd_pr__nfet_g5v0d10v5 L=0.5 W=10 nf=1 ad=2.9
+ as=2.9 pd=20.58 ps=20.58
+ nrd=0.029 nrs=0.029 sa=0 sb=0 sd=0 mult=1 m=1
XM_BIASN2 BIASP NB BIAS_ENN 0 sky130_fd_pr__nfet_g5v0d10v5 L=1 W=4 nf=1 ad=1.16
+ as=1.16 pd=8.58 ps=8.58
+ nrd=0.0725 nrs=0.0725 sa=0 sb=0 sd=0 mult=1 m=1
XM_BIASP1 BIASP BIASP VIN VIN sky130_fd_pr__pfet_g5v0d10v5 L=1 W=10 nf=2 ad=1.45
+ as=2.9 pd=10.58 ps=21.16
+ nrd=0.029 nrs=0.029 sa=0 sb=0 sd=0 mult=1 m=1
XM_ENP2 BIASP EN VIN VIN sky130_fd_pr__pfet_g5v0d10v5 L=0.5 W=10 nf=1 ad=2.9
+ as=2.9 pd=20.58 ps=20.58
+ nrd=0.029 nrs=0.029 sa=0 sb=0 sd=0 mult=1 m=1
ITAIL_IDEAL VINA EA_TAIL DC 3.2744u
XM_IN1 EA_D1 FB EA_TAIL VIN sky130_fd_pr__pfet_g5v0d10v5 L=2 W=10 nf=2 ad=1.45
+ as=2.9 pd=10.58 ps=21.16
+ nrd=0.029 nrs=0.029 sa=0 sb=0 sd=0 mult=1 m=1
XM_IN2 EA_D2 VREF EA_TAIL VIN sky130_fd_pr__pfet_g5v0d10v5 L=2 W=10 nf=2 ad=1.45
+ as=2.9 pd=10.58 ps=21.16
+ nrd=0.029 nrs=0.029 sa=0 sb=0 sd=0 mult=1 m=1
XM_MIR1 EA_D1 EA_D1 AMP_ENN 0 sky130_fd_pr__nfet_g5v0d10v5 L=4 W=10 nf=2 ad=1.45
+ as=2.9 pd=10.58 ps=21.16
+ nrd=0.029 nrs=0.029 sa=0 sb=0 sd=0 mult=1 m=1
XM_MIR2 EA_OUT EA_D1 AMP_ENN 0 sky130_fd_pr__nfet_g5v0d10v5 L=4 W=10 nf=2 ad=1.45
+ as=2.9 pd=10.58 ps=21.16
+ nrd=0.029 nrs=0.029 sa=0 sb=0 sd=0 mult=1 m=1
XM_ENN2 AMP_ENN EN 0 0 sky130_fd_pr__nfet_g5v0d10v5 L=0.5 W=10 nf=1 ad=2.9
+ as=2.9 pd=20.58 ps=20.58
+ nrd=0.029 nrs=0.029 sa=0 sb=0 sd=0 mult=1 m=1
XM_ENP EA_OUT EN VIN VIN sky130_fd_pr__pfet_g5v0d10v5 L=0.5 W=10 nf=1 ad=2.9
+ as=2.9 pd=20.58 ps=20.58
+ nrd=0.029 nrs=0.029 sa=0 sb=0 sd=0 mult=1 m=1
XM_MIR3 EA_D2 EA_D2 AMP_ENN 0 sky130_fd_pr__nfet_g5v0d10v5 L=4 W=10 nf=2 ad=1.45
+ as=2.9 pd=10.58 ps=21.16
+ nrd=0.029 nrs=0.029 sa=0 sb=0 sd=0 mult=1 m=1
XM_MIR4 PB EA_D2 AMP_ENN 0 sky130_fd_pr__nfet_g5v0d10v5 L=4 W=10 nf=2 ad=1.45
+ as=2.9 pd=10.58 ps=21.16
+ nrd=0.029 nrs=0.029 sa=0 sb=0 sd=0 mult=1 m=1
XM_MIRP1 PB PB VIN VIN sky130_fd_pr__pfet_g5v0d10v5 L=4 W=20 nf=4 ad=2.9
+ as=4.35 pd=21.16 ps=31.74
+ nrd=0.0145 nrs=0.0145 sa=0 sb=0 sd=0 mult=1 m=1
XM_MIRP2 EA_OUT PB VIN VIN sky130_fd_pr__pfet_g5v0d10v5 L=4 W=20 nf=4 ad=2.9
+ as=4.35 pd=21.16 ps=31.74
+ nrd=0.0145 nrs=0.0145 sa=0 sb=0 sd=0 mult=1 m=1
XM_ENP5 PB EN VIN VIN sky130_fd_pr__pfet_g5v0d10v5 L=0.5 W=2 nf=1 ad=0.58
+ as=0.58 pd=4.58 ps=4.58
+ nrd=0.145 nrs=0.145 sa=0 sb=0 sd=0 mult=1 m=1
XM_PASS VOUT EA_OUT VIN VIN sky130_fd_pr__pfet_g5v0d10v5 L=0.5 W=100 nf=25 ad=15.08
+ as=15.08 pd=111.54 ps=111.54
+ nrd=0.0029 nrs=0.0029 sa=0 sb=0 sd=0 mult=50 m=50
C_COMP VOUT EA_CZ 150p m=1
XR_CZ EA_CZ EA_OUT 0 sky130_fd_pr__res_xhigh_po W=0.42 L=52 mult=1 m=1
XR_FB_A VOUT FB 0 sky130_fd_pr__res_xhigh_po W=0.42 L=180 mult=1 m=1
XR_FB_B FB N_FBB 0 sky130_fd_pr__res_xhigh_po W=0.42 L=180 mult=1 m=1
XR_FB_C N_FBB 0 0 sky130_fd_pr__res_xhigh_po W=0.42 L=180 mult=1 m=1
XM_SENSE CL_SNS EA_OUT VIN VIN sky130_fd_pr__pfet_g5v0d10v5 L=0.5 W=0.42 nf=1 ad=0.1218
+ as=0.1218 pd=1.42 ps=1.42
+ nrd=0.690476 nrs=0.690476 sa=0 sb=0 sd=0 mult=2 m=2
XM_CLN1 CL_SNS CL_SNS AMP_ENN 0 sky130_fd_pr__nfet_g5v0d10v5 L=1 W=20 nf=1 ad=5.8
+ as=5.8 pd=40.58 ps=40.58
+ nrd=0.0145 nrs=0.0145 sa=0 sb=0 sd=0 mult=1 m=1
XM_CLN2 CL_CMP CL_SNS AMP_ENN 0 sky130_fd_pr__nfet_g5v0d10v5 L=1 W=1.6 nf=1 ad=0.464
+ as=0.464 pd=3.78 ps=3.78
+ nrd=0.18125 nrs=0.18125 sa=0 sb=0 sd=0 mult=1 m=1
XM_CLP CL_CMP BIASP VIN VIN sky130_fd_pr__pfet_g5v0d10v5 L=1 W=10 nf=2 ad=1.45
+ as=2.9 pd=10.58 ps=21.16
+ nrd=0.029 nrs=0.029 sa=0 sb=0 sd=0 mult=1 m=1
XM_CLIM EA_OUT CL_CMP VIN VIN sky130_fd_pr__pfet_g5v0d10v5 L=0.5 W=20 nf=4 ad=2.9
+ as=4.35 pd=21.16 ps=31.74
+ nrd=0.0145 nrs=0.0145 sa=0 sb=0 sd=0 mult=1 m=1
XM_ENP3 CL_CMP EN VIN VIN sky130_fd_pr__pfet_g5v0d10v5 L=0.5 W=2 nf=1 ad=0.58
+ as=0.58 pd=4.58 ps=4.58
+ nrd=0.145 nrs=0.145 sa=0 sb=0 sd=0 mult=1 m=1
C_CL VIN CL_CMP 1p m=1
XM_INVP ENB EN VIN VIN sky130_fd_pr__pfet_g5v0d10v5 L=0.5 W=2 nf=1 ad=0.58
+ as=0.58 pd=4.58 ps=4.58
+ nrd=0.145 nrs=0.145 sa=0 sb=0 sd=0 mult=1 m=1
XM_INVN ENB EN 0 0 sky130_fd_pr__nfet_g5v0d10v5 L=0.5 W=1 nf=1 ad=0.29
+ as=0.29 pd=2.58 ps=2.58
+ nrd=0.29 nrs=0.29 sa=0 sb=0 sd=0 mult=1 m=1
XM_SSDIS SS ENB 0 0 sky130_fd_pr__nfet_g5v0d10v5 L=0.5 W=2 nf=1 ad=0.58
+ as=0.58 pd=4.58 ps=4.58
+ nrd=0.145 nrs=0.145 sa=0 sb=0 sd=0 mult=1 m=1
XM_SSCHG SS BIASP VIN VIN sky130_fd_pr__pfet_g5v0d10v5 L=8 W=1 nf=1 ad=0.29
+ as=0.29 pd=2.58 ps=2.58
+ nrd=0.29 nrs=0.29 sa=0 sb=0 sd=0 mult=1 m=1
C_SS SS 0 10p m=1
XM_IN2S EA_D2 SS EA_TAIL VIN sky130_fd_pr__pfet_g5v0d10v5 L=2 W=10 nf=2 ad=1.45
+ as=2.9 pd=10.58 ps=21.16
+ nrd=0.029 nrs=0.029 sa=0 sb=0 sd=0 mult=1 m=1
XM_TSPS TS_SNS BIASP VIN VIN sky130_fd_pr__pfet_g5v0d10v5 L=1 W=1.25 nf=1 ad=0.3625
+ as=0.3625 pd=3.08 ps=3.08
+ nrd=0.232 nrs=0.232 sa=0 sb=0 sd=0 mult=1 m=1
XM_TSD1 TS_SNS TS_SNS TS_MID 0 sky130_fd_pr__nfet_g5v0d10v5 L=4 W=80 nf=16 ad=11.6
+ as=13.05 pd=84.64 ps=95.22
+ nrd=0.003625 nrs=0.003625 sa=0 sb=0 sd=0 mult=1 m=1
XM_TSD2 TS_MID TS_MID AMP_ENN 0 sky130_fd_pr__nfet_g5v0d10v5 L=4 W=80 nf=16 ad=11.6
+ as=13.05 pd=84.64 ps=95.22
+ nrd=0.003625 nrs=0.003625 sa=0 sb=0 sd=0 mult=1 m=1
XM_TSPR TS_REF BIASP VIN VIN sky130_fd_pr__pfet_g5v0d10v5 L=1 W=7 nf=1 ad=2.03
+ as=2.03 pd=14.58 ps=14.58
+ nrd=0.0414286 nrs=0.0414286 sa=0 sb=0 sd=0 mult=1 m=1
XM_TSR1 TS_REF TS_REF AMP_ENN 0 sky130_fd_pr__nfet_g5v0d10v5 L=2 W=0.42 nf=1 ad=0.1218
+ as=0.1218 pd=1.42 ps=1.42
+ nrd=0.690476 nrs=0.690476 sa=0 sb=0 sd=0 mult=1 m=1
XM_TSHUT EA_OUT TS_CMP VIN VIN sky130_fd_pr__pfet_g5v0d10v5 L=0.5 W=20 nf=4 ad=2.9
+ as=4.35 pd=21.16 ps=31.74
+ nrd=0.0145 nrs=0.0145 sa=0 sb=0 sd=0 mult=1 m=1
XM_ENP4 TS_CMP EN VIN VIN sky130_fd_pr__pfet_g5v0d10v5 L=0.5 W=2 nf=1 ad=0.58
+ as=0.58 pd=4.58 ps=4.58
+ nrd=0.145 nrs=0.145 sa=0 sb=0 sd=0 mult=1 m=1
C_TS VIN TS_CMP 1p m=1
XM_RCTAIL RC_TAIL NB AMP_ENN 0 sky130_fd_pr__nfet_g5v0d10v5 L=1 W=1 nf=1 ad=0.29
+ as=0.29 pd=2.58 ps=2.58
+ nrd=0.29 nrs=0.29 sa=0 sb=0 sd=0 mult=1 m=1
XM_RCN1 RC_A TS_SNS RC_TAIL 0 sky130_fd_pr__nfet_g5v0d10v5 L=2 W=10 nf=2 ad=1.45
+ as=2.9 pd=10.58 ps=21.16
+ nrd=0.029 nrs=0.029 sa=0 sb=0 sd=0 mult=1 m=1
XM_RCN2 RC_B TS_REF RC_TAIL 0 sky130_fd_pr__nfet_g5v0d10v5 L=2 W=10 nf=2 ad=1.45
+ as=2.9 pd=10.58 ps=21.16
+ nrd=0.029 nrs=0.029 sa=0 sb=0 sd=0 mult=1 m=1
XM_RCD1 RC_A RC_A VIN VIN sky130_fd_pr__pfet_g5v0d10v5 L=2 W=10 nf=2 ad=1.45
+ as=2.9 pd=10.58 ps=21.16
+ nrd=0.029 nrs=0.029 sa=0 sb=0 sd=0 mult=1 m=1
XM_RCD2 RC_B RC_B VIN VIN sky130_fd_pr__pfet_g5v0d10v5 L=2 W=10 nf=2 ad=1.45
+ as=2.9 pd=10.58 ps=21.16
+ nrd=0.029 nrs=0.029 sa=0 sb=0 sd=0 mult=1 m=1
XM_RCC1 RC_A RC_B VIN VIN sky130_fd_pr__pfet_g5v0d10v5 L=2 W=17 nf=2 ad=2.465
+ as=4.93 pd=17.58 ps=35.16
+ nrd=0.0170588 nrs=0.0170588 sa=0 sb=0 sd=0 mult=1 m=1
XM_RCC2 RC_B RC_A VIN VIN sky130_fd_pr__pfet_g5v0d10v5 L=2 W=17 nf=2 ad=2.465
+ as=4.93 pd=17.58 ps=35.16
+ nrd=0.0170588 nrs=0.0170588 sa=0 sb=0 sd=0 mult=1 m=1
XM_RCEA RC_A EN VIN VIN sky130_fd_pr__pfet_g5v0d10v5 L=0.5 W=2 nf=1 ad=0.58
+ as=0.58 pd=4.58 ps=4.58
+ nrd=0.145 nrs=0.145 sa=0 sb=0 sd=0 mult=1 m=1
XM_RCEB RC_B EN VIN VIN sky130_fd_pr__pfet_g5v0d10v5 L=0.5 W=2 nf=1 ad=0.58
+ as=0.58 pd=4.58 ps=4.58
+ nrd=0.145 nrs=0.145 sa=0 sb=0 sd=0 mult=1 m=1
XM_RCOP TS_CMP RC_A VIN VIN sky130_fd_pr__pfet_g5v0d10v5 L=1 W=2 nf=1 ad=0.58
+ as=0.58 pd=4.58 ps=4.58
+ nrd=0.145 nrs=0.145 sa=0 sb=0 sd=0 mult=1 m=1
XM_RCOS TS_CMP NB AMP_ENN 0 sky130_fd_pr__nfet_g5v0d10v5 L=2 W=0.5 nf=1 ad=0.145
+ as=0.145 pd=1.58 ps=1.58
+ nrd=0.58 nrs=0.58 sa=0 sb=0 sd=0 mult=1 m=1
XM_RCEO TS_CMP EN VIN VIN sky130_fd_pr__pfet_g5v0d10v5 L=0.5 W=2 nf=1 ad=0.58
+ as=0.58 pd=4.58 ps=4.58
+ nrd=0.145 nrs=0.145 sa=0 sb=0 sd=0 mult=1 m=1
.ends

.control
save all @m.xldo.xm_pass.msky130_fd_pr__pfet_g5v0d10v5[id] @m.xldo.xm_pass.msky130_fd_pr__pfet_g5v0d10v5[vgs] @m.xldo.xm_pass.msky130_fd_pr__pfet_g5v0d10v5[vds] @m.xldo.xm_pass.msky130_fd_pr__pfet_g5v0d10v5[vdsat] @m.xldo.xm_pass.msky130_fd_pr__pfet_g5v0d10v5[vth] @m.xldo.xm_pass.msky130_fd_pr__pfet_g5v0d10v5[gm] @m.xldo.xm_sense.msky130_fd_pr__pfet_g5v0d10v5[id] @m.xldo.xm_sense.msky130_fd_pr__pfet_g5v0d10v5[vgs] @m.xldo.xm_sense.msky130_fd_pr__pfet_g5v0d10v5[vds] @m.xldo.xm_clim.msky130_fd_pr__pfet_g5v0d10v5[id] @m.xldo.xm_clim.msky130_fd_pr__pfet_g5v0d10v5[vgs] @m.xldo.xm_clim.msky130_fd_pr__pfet_g5v0d10v5[vds] @m.xldo.xm_clim.msky130_fd_pr__pfet_g5v0d10v5[vdsat] @m.xldo.xm_tshut.msky130_fd_pr__pfet_g5v0d10v5[id] @m.xldo.xm_tshut.msky130_fd_pr__pfet_g5v0d10v5[vgs] @m.xldo.xm_tshut.msky130_fd_pr__pfet_g5v0d10v5[vds] @m.xldo.xm_mirp2.msky130_fd_pr__pfet_g5v0d10v5[id] @m.xldo.xm_mirp2.msky130_fd_pr__pfet_g5v0d10v5[vgs] @m.xldo.xm_mirp2.msky130_fd_pr__pfet_g5v0d10v5[vds] @m.xldo.xm_mirp2.msky130_fd_pr__pfet_g5v0d10v5[vdsat] @m.xldo.xm_mir2.msky130_fd_pr__nfet_g5v0d10v5[id] @m.xldo.xm_mir2.msky130_fd_pr__nfet_g5v0d10v5[vgs] @m.xldo.xm_mir2.msky130_fd_pr__nfet_g5v0d10v5[vds] @m.xldo.xm_mir2.msky130_fd_pr__nfet_g5v0d10v5[vdsat] @m.xldo.xm_in1.msky130_fd_pr__pfet_g5v0d10v5[id] @m.xldo.xm_in2.msky130_fd_pr__pfet_g5v0d10v5[id] @m.xldo.xm_biasn1.msky130_fd_pr__nfet_g5v0d10v5[id] @m.xldo.xm_biasp1.msky130_fd_pr__pfet_g5v0d10v5[id]
* ONE cold-start transient, not a `dc VVIN` sweep (issue #178, the #171
* initial-condition contract): `uic` starts every node at its natural cold
* value with EN low, the testbench's VEN steps high at 100us, VIN rises to
* the corner's own 'vsup' top by 100us, the ideal 50mA sink ramps on over
* 2.5-2.6ms once the loop is up, and the block is settled by 5.5ms. VIN is
* then ramped DOWN from 'vsup' to 'vsup'-2.13V over 6ms-14ms -- a CONSTANT
* 266.3 V/s at every corner, quasi-static (see the testbench header for the
* ramp-rate measurement and for why the endpoint tracks 'vsup' instead of
* being pinned at 1.5V) -- and the dropout crossing is read off that ramp.
* SUPPLY CONVENTION (issue #187): VIN's top is 'vsup' and EN's high level
* is that same 'vsup', so EN is AT the VIN rail -- the DUT's documented
* enable interface (design/README.md "Enable/shutdown": active-high,
* full-rail 0V/VIN). Through record 20260926-043132-eba96ae VIN was pinned
* at 3.63V while EN kept 'vsup', which put EN 0.66V below VIN at the
* '*_2.97v' corners and stopped the block coming up at fs/125C.
* There is no operating-point solve in the
* deck at all -- the contract's `uic` + EN-edge shape, the one PR #170
* landed for sim/mc-output-accuracy and PR for #172 landed for
* line-/load-regulation. `td=6m` keeps the `fall=1` search off the
* start-up ramp's own rise, so the crossing found is the dropout event.
tran 10u 14m uic
meas tran dropout_vin_x find v(vin) when v(vout)=1.764 fall=1 td=6m
meas tran vout_at_max_vin_v avg v(vout) from=5.5m to=6m
wrdata probeA.dat v(vin) v(vout) v(en) v(xldo.ea_out) v(xldo.biasp) v(xldo.ea_tail) v(xldo.ea_d1) v(xldo.ea_d2) v(xldo.pb) v(xldo.cl_cmp) v(xldo.cl_sns) v(xldo.ts_cmp) v(xldo.amp_enn) v(xldo.fb) v(xldo.nb) i(vvin) i(vvina) @m.xldo.xm_pass.msky130_fd_pr__pfet_g5v0d10v5[id] @m.xldo.xm_pass.msky130_fd_pr__pfet_g5v0d10v5[vgs] @m.xldo.xm_pass.msky130_fd_pr__pfet_g5v0d10v5[vds] @m.xldo.xm_pass.msky130_fd_pr__pfet_g5v0d10v5[vdsat] @m.xldo.xm_pass.msky130_fd_pr__pfet_g5v0d10v5[vth] @m.xldo.xm_pass.msky130_fd_pr__pfet_g5v0d10v5[gm] @m.xldo.xm_sense.msky130_fd_pr__pfet_g5v0d10v5[id] @m.xldo.xm_sense.msky130_fd_pr__pfet_g5v0d10v5[vgs] @m.xldo.xm_sense.msky130_fd_pr__pfet_g5v0d10v5[vds] @m.xldo.xm_clim.msky130_fd_pr__pfet_g5v0d10v5[id] @m.xldo.xm_clim.msky130_fd_pr__pfet_g5v0d10v5[vgs] @m.xldo.xm_clim.msky130_fd_pr__pfet_g5v0d10v5[vds] @m.xldo.xm_clim.msky130_fd_pr__pfet_g5v0d10v5[vdsat] @m.xldo.xm_tshut.msky130_fd_pr__pfet_g5v0d10v5[id] @m.xldo.xm_tshut.msky130_fd_pr__pfet_g5v0d10v5[vgs] @m.xldo.xm_tshut.msky130_fd_pr__pfet_g5v0d10v5[vds] @m.xldo.xm_mirp2.msky130_fd_pr__pfet_g5v0d10v5[id] @m.xldo.xm_mirp2.msky130_fd_pr__pfet_g5v0d10v5[vgs] @m.xldo.xm_mirp2.msky130_fd_pr__pfet_g5v0d10v5[vds] @m.xldo.xm_mirp2.msky130_fd_pr__pfet_g5v0d10v5[vdsat] @m.xldo.xm_mir2.msky130_fd_pr__nfet_g5v0d10v5[id] @m.xldo.xm_mir2.msky130_fd_pr__nfet_g5v0d10v5[vgs] @m.xldo.xm_mir2.msky130_fd_pr__nfet_g5v0d10v5[vds] @m.xldo.xm_mir2.msky130_fd_pr__nfet_g5v0d10v5[vdsat] @m.xldo.xm_in1.msky130_fd_pr__pfet_g5v0d10v5[id] @m.xldo.xm_in2.msky130_fd_pr__pfet_g5v0d10v5[id] @m.xldo.xm_biasn1.msky130_fd_pr__nfet_g5v0d10v5[id] @m.xldo.xm_biasp1.msky130_fd_pr__pfet_g5v0d10v5[id]
let meas_dropout_v = dropout_vin_x - 1.764
let meas_vout_at_max_vin_v = vout_at_max_vin_v
print meas_dropout_v
print meas_vout_at_max_vin_v
quit
.endc
.end
