* dropout-vs-load corner deck -- generated by sim/bin/corner-run.py, do not edit
* corner: tt_27c_3.30v
.param vsup=3.3
.option wnflag=1
.temp 27
.lib "/home/ubuntu/.volare/sky130A/libs.tech/combined/sky130.lib.spice" tt
** sch_path: sim/dropout-vs-load/testbench/tb_dropout_vs_load.sch
**.subckt tb_dropout_vs_load
VVIN VIN 0 PWL(0 0 100u 'vsup' 6m 'vsup' 14m 'vsup-2.13')
.save i(vvin)
VEN EN 0 PULSE(0 'vsup' 100u 1u 1u 100 200)
.save i(ven)
VVREF VREF 0 1.2
.save i(vvref)
xldo VOUT VREF EN VIN ldo_3v3in_1v8out
COUT VOUT VESR 1u m=1
RESR VESR 0 10m m=1
ILOAD VOUT 0 PWL(0 0 2.5m 0 2.6m 50m)
**.ends

* expanding   symbol:  design/ldo_3v3in_1v8out.sym # of pins=4
** sym_path: design/ldo_3v3in_1v8out.sym
** sch_path: design/ldo_3v3in_1v8out.sch
.subckt ldo_3v3in_1v8out VOUT VREF EN VIN
*.ipin VIN
*.ipin EN
*.ipin VREF
*.opin VOUT
XR_BIAS VIN NB 0 sky130_fd_pr__res_high_po W=0.42 L=1500 mult=1 m=1
XM_BIASN1 NB NB BIAS_ENN 0 sky130_fd_pr__nfet_g5v0d10v5 L=1 W=4 nf=1 ad=1.16 as=1.16 pd=8.58 ps=8.58 nrd=0.0725 nrs=0.0725 sa=0
+ sb=0 sd=0 mult=1 m=1
XM_ENN BIAS_ENN EN 0 0 sky130_fd_pr__nfet_g5v0d10v5 L=0.5 W=10 nf=1 ad=2.9 as=2.9 pd=20.58 ps=20.58 nrd=0.029 nrs=0.029 sa=0 sb=0
+ sd=0 mult=1 m=1
XM_BIASN2 BIASP NB BIAS_ENN 0 sky130_fd_pr__nfet_g5v0d10v5 L=1 W=4 nf=1 ad=1.16 as=1.16 pd=8.58 ps=8.58 nrd=0.0725 nrs=0.0725 sa=0
+ sb=0 sd=0 mult=1 m=1
XM_BIASP1 BIASP BIASP VIN VIN sky130_fd_pr__pfet_g5v0d10v5 L=1 W=10 nf=2 ad=1.45 as=2.9 pd=10.58 ps=21.16 nrd=0.029 nrs=0.029 sa=0
+ sb=0 sd=0 mult=1 m=1
XM_ENP2 BIASP EN VIN VIN sky130_fd_pr__pfet_g5v0d10v5 L=0.5 W=10 nf=1 ad=2.9 as=2.9 pd=20.58 ps=20.58 nrd=0.029 nrs=0.029 sa=0
+ sb=0 sd=0 mult=1 m=1
XM_ENN2 AMP_ENN EN 0 0 sky130_fd_pr__nfet_g5v0d10v5 L=0.5 W=10 nf=1 ad=2.9 as=2.9 pd=20.58 ps=20.58 nrd=0.029 nrs=0.029 sa=0 sb=0
+ sd=0 mult=1 m=1
XM_ENP EA_OUT EN VIN VIN sky130_fd_pr__pfet_g5v0d10v5 L=0.5 W=10 nf=1 ad=2.9 as=2.9 pd=20.58 ps=20.58 nrd=0.029 nrs=0.029 sa=0
+ sb=0 sd=0 mult=1 m=1
XM_ENP5 ND1 EN VIN VIN sky130_fd_pr__pfet_g5v0d10v5 L=0.5 W=2 nf=1 ad=0.58 as=0.58 pd=4.58 ps=4.58 nrd=0.145 nrs=0.145 sa=0 sb=0
+ sd=0 mult=1 m=1
XM_PASS VOUT EA_OUT VIN VIN sky130_fd_pr__pfet_g5v0d10v5 L=0.5 W=100 nf=25 ad=15.08 as=15.08 pd=111.54 ps=111.54 nrd=0.0029
+ nrs=0.0029 sa=0 sb=0 sd=0 mult=50 m=50
C_COMP VOUT EA_CZ 150p m=1
XR_CZ EA_CZ EA_OUT 0 sky130_fd_pr__res_xhigh_po W=0.42 L=52 mult=1 m=1
XR_FB_A VOUT FB 0 sky130_fd_pr__res_xhigh_po W=0.42 L=180 mult=1 m=1
XR_FB_B FB N_FBB 0 sky130_fd_pr__res_xhigh_po W=0.42 L=180 mult=1 m=1
XR_FB_C N_FBB 0 0 sky130_fd_pr__res_xhigh_po W=0.42 L=180 mult=1 m=1
XM_SENSE CL_SNS EA_OUT VIN VIN sky130_fd_pr__pfet_g5v0d10v5 L=0.5 W=0.42 nf=1 ad=0.1218 as=0.1218 pd=1.42 ps=1.42
+ nrd=0.69047619047619 nrs=0.69047619047619 sa=0 sb=0 sd=0 mult=2 m=2
XM_CLN1 CL_SNS CL_SNS AMP_ENN 0 sky130_fd_pr__nfet_g5v0d10v5 L=1 W=20 nf=1 ad=5.8 as=5.8 pd=40.58 ps=40.58 nrd=0.0145 nrs=0.0145
+ sa=0 sb=0 sd=0 mult=1 m=1
XM_CLN2 CL_CMP CL_SNS AMP_ENN 0 sky130_fd_pr__nfet_g5v0d10v5 L=1 W=1.6 nf=1 ad=0.464 as=0.464 pd=3.78 ps=3.78 nrd=0.18125
+ nrs=0.18125 sa=0 sb=0 sd=0 mult=1 m=1
XM_CLP CL_CMP PBR VIN VIN sky130_fd_pr__pfet_g5v0d10v5 L=1 W=10 nf=2 ad=1.45 as=2.9 pd=10.58 ps=21.16 nrd=0.029 nrs=0.029 sa=0
+ sb=0 sd=0 mult=1 m=1
XM_CLIM EA_OUT CL_CMP VIN VIN sky130_fd_pr__pfet_g5v0d10v5 L=0.5 W=20 nf=4 ad=2.9 as=4.35 pd=21.16 ps=31.74 nrd=0.0145 nrs=0.0145
+ sa=0 sb=0 sd=0 mult=1 m=1
XM_ENP3 CL_CMP EN VIN VIN sky130_fd_pr__pfet_g5v0d10v5 L=0.5 W=2 nf=1 ad=0.58 as=0.58 pd=4.58 ps=4.58 nrd=0.145 nrs=0.145 sa=0
+ sb=0 sd=0 mult=1 m=1
C_CL VIN CL_CMP 1p m=1
XM_INVP ENB EN VIN VIN sky130_fd_pr__pfet_g5v0d10v5 L=0.5 W=2 nf=1 ad=0.58 as=0.58 pd=4.58 ps=4.58 nrd=0.145 nrs=0.145 sa=0 sb=0
+ sd=0 mult=1 m=1
XM_INVN ENB EN 0 0 sky130_fd_pr__nfet_g5v0d10v5 L=0.5 W=1 nf=1 ad=0.29 as=0.29 pd=2.58 ps=2.58 nrd=0.29 nrs=0.29 sa=0 sb=0 sd=0
+ mult=1 m=1
XM_SSDIS SS ENB 0 0 sky130_fd_pr__nfet_g5v0d10v5 L=0.5 W=2 nf=1 ad=0.58 as=0.58 pd=4.58 ps=4.58 nrd=0.145 nrs=0.145 sa=0 sb=0 sd=0
+ mult=1 m=1
XM_SSCHG SS BIASP VIN VIN sky130_fd_pr__pfet_g5v0d10v5 L=8 W=1 nf=1 ad=0.29 as=0.29 pd=2.58 ps=2.58 nrd=0.29 nrs=0.29 sa=0 sb=0
+ sd=0 mult=1 m=1
C_SS SS 0 10p m=1
XM_TSPS TS_SNS BIASP VIN VIN sky130_fd_pr__pfet_g5v0d10v5 L=1 W=1.25 nf=1 ad=0.3625 as=0.3625 pd=3.08 ps=3.08 nrd=0.232 nrs=0.232
+ sa=0 sb=0 sd=0 mult=1 m=1
XM_TSD1 TS_SNS TS_SNS TS_MID 0 sky130_fd_pr__nfet_g5v0d10v5 L=4 W=80 nf=16 ad=11.6 as=13.05 pd=84.64 ps=95.22 nrd=0.003625
+ nrs=0.003625 sa=0 sb=0 sd=0 mult=1 m=1
XM_TSD2 TS_MID TS_MID AMP_ENN 0 sky130_fd_pr__nfet_g5v0d10v5 L=4 W=80 nf=16 ad=11.6 as=13.05 pd=84.64 ps=95.22 nrd=0.003625
+ nrs=0.003625 sa=0 sb=0 sd=0 mult=1 m=1
XM_TSPR TS_REF BIASP VIN VIN sky130_fd_pr__pfet_g5v0d10v5 L=1 W=7 nf=1 ad=2.03 as=2.03 pd=14.58 ps=14.58 nrd=0.0414285714285714
+ nrs=0.0414285714285714 sa=0 sb=0 sd=0 mult=1 m=1
XM_TSR1 TS_REF TS_REF AMP_ENN 0 sky130_fd_pr__nfet_g5v0d10v5 L=2 W=0.42 nf=1 ad=0.1218 as=0.1218 pd=1.42 ps=1.42
+ nrd=0.69047619047619 nrs=0.69047619047619 sa=0 sb=0 sd=0 mult=1 m=1
XM_TSHUT EA_OUT TS_CMP VIN VIN sky130_fd_pr__pfet_g5v0d10v5 L=0.5 W=20 nf=4 ad=2.9 as=4.35 pd=21.16 ps=31.74 nrd=0.0145 nrs=0.0145
+ sa=0 sb=0 sd=0 mult=1 m=1
XM_ENP4 TS_CMP EN VIN VIN sky130_fd_pr__pfet_g5v0d10v5 L=0.5 W=2 nf=1 ad=0.58 as=0.58 pd=4.58 ps=4.58 nrd=0.145 nrs=0.145 sa=0
+ sb=0 sd=0 mult=1 m=1
C_TS VIN TS_CMP 1p m=1
XM_RCTAIL RC_TAIL NB AMP_ENN 0 sky130_fd_pr__nfet_g5v0d10v5 L=1 W=1 nf=1 ad=0.29 as=0.29 pd=2.58 ps=2.58 nrd=0.29 nrs=0.29 sa=0
+ sb=0 sd=0 mult=1 m=1
XM_RCN1 RC_A TS_SNS RC_TAIL 0 sky130_fd_pr__nfet_g5v0d10v5 L=2 W=10 nf=2 ad=1.45 as=2.9 pd=10.58 ps=21.16 nrd=0.029 nrs=0.029 sa=0
+ sb=0 sd=0 mult=1 m=1
XM_RCN2 RC_B TS_REF RC_TAIL 0 sky130_fd_pr__nfet_g5v0d10v5 L=2 W=10 nf=2 ad=1.45 as=2.9 pd=10.58 ps=21.16 nrd=0.029 nrs=0.029 sa=0
+ sb=0 sd=0 mult=1 m=1
XM_RCD1 RC_A RC_A VIN VIN sky130_fd_pr__pfet_g5v0d10v5 L=2 W=10 nf=2 ad=1.45 as=2.9 pd=10.58 ps=21.16 nrd=0.029 nrs=0.029 sa=0
+ sb=0 sd=0 mult=1 m=1
XM_RCD2 RC_B RC_B VIN VIN sky130_fd_pr__pfet_g5v0d10v5 L=2 W=10 nf=2 ad=1.45 as=2.9 pd=10.58 ps=21.16 nrd=0.029 nrs=0.029 sa=0
+ sb=0 sd=0 mult=1 m=1
XM_RCC1 RC_A RC_B VIN VIN sky130_fd_pr__pfet_g5v0d10v5 L=2 W=17 nf=2 ad=2.465 as=4.93 pd=17.58 ps=35.16 nrd=0.0170588235294118
+ nrs=0.0170588235294118 sa=0 sb=0 sd=0 mult=1 m=1
XM_RCC2 RC_B RC_A VIN VIN sky130_fd_pr__pfet_g5v0d10v5 L=2 W=17 nf=2 ad=2.465 as=4.93 pd=17.58 ps=35.16 nrd=0.0170588235294118
+ nrs=0.0170588235294118 sa=0 sb=0 sd=0 mult=1 m=1
XM_RCEA RC_A EN VIN VIN sky130_fd_pr__pfet_g5v0d10v5 L=0.5 W=2 nf=1 ad=0.58 as=0.58 pd=4.58 ps=4.58 nrd=0.145 nrs=0.145 sa=0 sb=0
+ sd=0 mult=1 m=1
XM_RCEB RC_B EN VIN VIN sky130_fd_pr__pfet_g5v0d10v5 L=0.5 W=2 nf=1 ad=0.58 as=0.58 pd=4.58 ps=4.58 nrd=0.145 nrs=0.145 sa=0 sb=0
+ sd=0 mult=1 m=1
XM_RCOP TS_CMP RC_A VIN VIN sky130_fd_pr__pfet_g5v0d10v5 L=1 W=2 nf=1 ad=0.58 as=0.58 pd=4.58 ps=4.58 nrd=0.145 nrs=0.145 sa=0
+ sb=0 sd=0 mult=1 m=1
XM_RCOS TS_CMP NB AMP_ENN 0 sky130_fd_pr__nfet_g5v0d10v5 L=2 W=0.5 nf=1 ad=0.145 as=0.145 pd=1.58 ps=1.58 nrd=0.58 nrs=0.58 sa=0
+ sb=0 sd=0 mult=1 m=1
XM_RCEO TS_CMP EN VIN VIN sky130_fd_pr__pfet_g5v0d10v5 L=0.5 W=2 nf=1 ad=0.58 as=0.58 pd=4.58 ps=4.58 nrd=0.145 nrs=0.145 sa=0
+ sb=0 sd=0 mult=1 m=1
* --- issue #357 candidate rev1: VREF-referenced bias + NMOS-input OTA (diagnostic) ---
XM_VRF PBR VREF NVR 0 sky130_fd_pr__nfet_g5v0d10v5 L=1 W=10 nf=2 ad=1.45
+ as=2.9 pd=10.58 ps=21.16
+ nrd=0.029 nrs=0.029 sa=0 sb=0 sd=0 mult=1 m=1
XR_VR NVR AMP_ENN 0 sky130_fd_pr__res_high_po W=0.42 L=550 mult=1 m=1
XM_PBR PBR PBR VIN VIN sky130_fd_pr__pfet_g5v0d10v5 L=1 W=2.5 nf=1 ad=0.725
+ as=0.725 pd=5.58 ps=5.58
+ nrd=0.116 nrs=0.116 sa=0 sb=0 sd=0 mult=1 m=1
XM_PBN NBR PBR VIN VIN sky130_fd_pr__pfet_g5v0d10v5 L=1 W=1.75 nf=1 ad=0.5075
+ as=0.5075 pd=4.08 ps=4.08
+ nrd=0.165714 nrs=0.165714 sa=0 sb=0 sd=0 mult=1 m=1
XM_NBR NBR NBR AMP_ENN 0 sky130_fd_pr__nfet_g5v0d10v5 L=2 W=2.5 nf=1 ad=0.725
+ as=0.725 pd=5.58 ps=5.58
+ nrd=0.116 nrs=0.116 sa=0 sb=0 sd=0 mult=1 m=1
XM_NTAIL NTAIL NBR AMP_ENN 0 sky130_fd_pr__nfet_g5v0d10v5 L=2 W=12 nf=3 ad=2.32
+ as=2.32 pd=17.16 ps=17.16
+ nrd=0.0241667 nrs=0.0241667 sa=0 sb=0 sd=0 mult=1 m=1
XM_NIN1 NX1 FB NTAIL 0 sky130_fd_pr__nfet_g5v0d10v5 L=2 W=10 nf=2 ad=1.45
+ as=2.9 pd=10.58 ps=21.16
+ nrd=0.029 nrs=0.029 sa=0 sb=0 sd=0 mult=1 m=1
XM_NIN1C ND1 VIN NX1 0 sky130_fd_pr__nfet_g5v0d10v5 L=1 W=10 nf=2 ad=1.45
+ as=2.9 pd=10.58 ps=21.16
+ nrd=0.029 nrs=0.029 sa=0 sb=0 sd=0 mult=1 m=1
XM_NIN2 NX2 VREF NTAIL 0 sky130_fd_pr__nfet_g5v0d10v5 L=2 W=10 nf=2 ad=1.45
+ as=2.9 pd=10.58 ps=21.16
+ nrd=0.029 nrs=0.029 sa=0 sb=0 sd=0 mult=1 m=1
XM_NIN2S ND2 SS NX2 0 sky130_fd_pr__nfet_g5v0d10v5 L=1 W=10 nf=2 ad=1.45
+ as=2.9 pd=10.58 ps=21.16
+ nrd=0.029 nrs=0.029 sa=0 sb=0 sd=0 mult=1 m=1
XM_PD1 ND1 ND1 VIN VIN sky130_fd_pr__pfet_g5v0d10v5 L=4 W=20 nf=4 ad=2.9
+ as=4.35 pd=21.16 ps=31.74
+ nrd=0.0145 nrs=0.0145 sa=0 sb=0 sd=0 mult=1 m=1
XM_PO1 EA_OUT ND1 VIN VIN sky130_fd_pr__pfet_g5v0d10v5 L=4 W=20 nf=4 ad=2.9
+ as=4.35 pd=21.16 ps=31.74
+ nrd=0.0145 nrs=0.0145 sa=0 sb=0 sd=0 mult=1 m=1
XM_PD2 ND2 ND2 VIN VIN sky130_fd_pr__pfet_g5v0d10v5 L=4 W=20 nf=4 ad=2.9
+ as=4.35 pd=21.16 ps=31.74
+ nrd=0.0145 nrs=0.0145 sa=0 sb=0 sd=0 mult=1 m=1
XM_PO2 NM ND2 VIN VIN sky130_fd_pr__pfet_g5v0d10v5 L=4 W=20 nf=4 ad=2.9
+ as=4.35 pd=21.16 ps=31.74
+ nrd=0.0145 nrs=0.0145 sa=0 sb=0 sd=0 mult=1 m=1
XM_NMD NM NM AMP_ENN 0 sky130_fd_pr__nfet_g5v0d10v5 L=4 W=10 nf=2 ad=1.45
+ as=2.9 pd=10.58 ps=21.16
+ nrd=0.029 nrs=0.029 sa=0 sb=0 sd=0 mult=1 m=1
XM_NMO EA_OUT NM AMP_ENN 0 sky130_fd_pr__nfet_g5v0d10v5 L=4 W=10 nf=2 ad=1.45
+ as=2.9 pd=10.58 ps=21.16
+ nrd=0.029 nrs=0.029 sa=0 sb=0 sd=0 mult=1 m=1
XM_ENP6 PBR EN VIN VIN sky130_fd_pr__pfet_g5v0d10v5 L=0.5 W=2 nf=1 ad=0.58
+ as=0.58 pd=4.58 ps=4.58
+ nrd=0.145 nrs=0.145 sa=0 sb=0 sd=0 mult=1 m=1
XM_ENP7 ND2 EN VIN VIN sky130_fd_pr__pfet_g5v0d10v5 L=0.5 W=2 nf=1 ad=0.58
+ as=0.58 pd=4.58 ps=4.58
+ nrd=0.145 nrs=0.145 sa=0 sb=0 sd=0 mult=1 m=1
.ends

.save @m.xldo.xm_ntail.msky130_fd_pr__nfet_g5v0d10v5[id]
.save @m.xldo.xm_clim.msky130_fd_pr__pfet_g5v0d10v5[id]
.save @m.xldo.xm_clim.msky130_fd_pr__pfet_g5v0d10v5[vgs]
.save @m.xldo.xm_vrf.msky130_fd_pr__nfet_g5v0d10v5[id]
.save @m.xldo.xm_clp.msky130_fd_pr__pfet_g5v0d10v5[id]
.control
save all
* ONE cold-start transient, not a `dc VVIN` sweep (issue #178, the #171
* initial-condition contract): `uic` starts every node at its natural cold
* value with EN low, the testbench's VEN steps high at 100us, VIN rises to
* the corner's own 'vsup' top by 100us, the ideal 50mA sink ramps on over
* 2.5-2.6ms once the loop is up, and the block is settled by 5.5ms. VIN is
* then ramped DOWN from 'vsup' to 'vsup'-2.13V over 6ms-14ms -- a CONSTANT
* 266.3 V/s at every corner, quasi-static (see the testbench header for the
* ramp-rate measurement and for why the endpoint tracks 'vsup' instead of
* being pinned at 1.5V) -- and the dropout crossing is read off that ramp.
* SUPPLY CONVENTION (issue #187): VIN's top is 'vsup' and EN's high level
* is that same 'vsup', so EN is AT the VIN rail -- the DUT's documented
* enable interface (design/README.md "Enable/shutdown": active-high,
* full-rail 0V/VIN). Through record 20260926-043132-eba96ae VIN was pinned
* at 3.63V while EN kept 'vsup', which put EN 0.66V below VIN at the
* '*_2.97v' corners and stopped the block coming up at fs/125C.
* There is no operating-point solve in the
* deck at all -- the contract's `uic` + EN-edge shape, the one PR #170
* landed for sim/mc-output-accuracy and PR for #172 landed for
* line-/load-regulation. `td=6m` keeps the `fall=1` search off the
* start-up ramp's own rise, so the crossing found is the dropout event.
tran 10u 14m uic
meas tran dropout_vin_x find v(vin) when v(vout)=1.764 fall=1 td=6m
meas tran vout_at_max_vin_v avg v(vout) from=5.5m to=6m
meas tran ea_out_at_x find v(xldo.ea_out) when v(vout)=1.764 fall=1 td=6m
meas tran tail_i_at_x find @m.xldo.xm_ntail.msky130_fd_pr__nfet_g5v0d10v5[id] when v(vout)=1.764 fall=1 td=6m
meas tran mclim_i_at_x find @m.xldo.xm_clim.msky130_fd_pr__pfet_g5v0d10v5[id] when v(vout)=1.764 fall=1 td=6m
meas tran vout_at_2v064 find v(vout) when v(vin)=2.064 fall=1 td=6m
meas tran mclim_vgs_at_2v064 find @m.xldo.xm_clim.msky130_fd_pr__pfet_g5v0d10v5[vgs] when v(vin)=2.064 fall=1 td=6m
meas tran mclim_i_at_2v064 find @m.xldo.xm_clim.msky130_fd_pr__pfet_g5v0d10v5[id] when v(vin)=2.064 fall=1 td=6m
meas tran tail_i_set avg @m.xldo.xm_ntail.msky130_fd_pr__nfet_g5v0d10v5[id] from=5.5m to=6m
meas tran biasref_i_set avg @m.xldo.xm_vrf.msky130_fd_pr__nfet_g5v0d10v5[id] from=5.5m to=6m
let meas_dropout_v = dropout_vin_x - 1.764
let meas_vout_at_max_vin_v = vout_at_max_vin_v
print meas_dropout_v
print meas_vout_at_max_vin_v
quit
.endc
.end
