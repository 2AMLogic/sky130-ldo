** sch_path: sim/thermal-regen-cmp/testbench/tb_thermal_regen_cmp.sch
**.subckt tb_thermal_regen_cmp
VVIN VIN 0 'vsup'
.save i(vvin)
VEN EN 0 PWL(0 0 2u 0 3u 'vsup' 60u 'vsup' 61u 'en_dip' 75u 'en_dip' 76u 'vsup')
.save i(ven)
VVX TS_SNS SNS PWL(0 0 20u 0 21u 'vx_amp' 40u 'vx_amp' 41u 0)
.save i(vvx)
XR_BIAS VIN NB 0 sky130_fd_pr__res_high_po W=0.42 L=1500 mult=1 m=1
XM_BIASN1 NB NB BIAS_ENN 0 sky130_fd_pr__nfet_g5v0d10v5 L=1 W=4 nf=1 ad=1.16 as=1.16 pd=8.58 ps=8.58 nrd=0.0725 nrs=0.0725 sa=0
+ sb=0 sd=0 mult=1 m=1
XM_BIASN2 BIASP NB BIAS_ENN 0 sky130_fd_pr__nfet_g5v0d10v5 L=1 W=4 nf=1 ad=1.16 as=1.16 pd=8.58 ps=8.58 nrd=0.0725 nrs=0.0725 sa=0
+ sb=0 sd=0 mult=1 m=1
XM_ENN BIAS_ENN EN 0 0 sky130_fd_pr__nfet_g5v0d10v5 L=0.5 W=10 nf=1 ad=2.9 as=2.9 pd=20.58 ps=20.58 nrd=0.029 nrs=0.029 sa=0 sb=0
+ sd=0 mult=1 m=1
XM_BIASP1 BIASP BIASP VIN VIN sky130_fd_pr__pfet_g5v0d10v5 L=1 W=10 nf=2 ad=1.45 as=2.9 pd=10.58 ps=21.16 nrd=0.029 nrs=0.029 sa=0
+ sb=0 sd=0 mult=1 m=1
XM_ENP2 BIASP EN VIN VIN sky130_fd_pr__pfet_g5v0d10v5 L=0.5 W=10 nf=1 ad=2.9 as=2.9 pd=20.58 ps=20.58 nrd=0.029 nrs=0.029 sa=0
+ sb=0 sd=0 mult=1 m=1
XM_ENN2 AMP_ENN EN 0 0 sky130_fd_pr__nfet_g5v0d10v5 L=0.5 W=10 nf=1 ad=2.9 as=2.9 pd=20.58 ps=20.58 nrd=0.029 nrs=0.029 sa=0 sb=0
+ sd=0 mult=1 m=1
XM_TSPS SNS BIASP VIN VIN sky130_fd_pr__pfet_g5v0d10v5 L=1 W=1.25 nf=1 ad=0.3625 as=0.3625 pd=3.08 ps=3.08 nrd=0.232 nrs=0.232
+ sa=0 sb=0 sd=0 mult=1 m=1
XM_TSD1 SNS SNS TS_MID 0 sky130_fd_pr__nfet_g5v0d10v5 L=4 W=80 nf=16 ad=11.6 as=13.05 pd=84.64 ps=95.22 nrd=0.003625 nrs=0.003625
+ sa=0 sb=0 sd=0 mult=1 m=1
XM_TSD2 TS_MID TS_MID AMP_ENN 0 sky130_fd_pr__nfet_g5v0d10v5 L=4 W=80 nf=16 ad=11.6 as=13.05 pd=84.64 ps=95.22 nrd=0.003625
+ nrs=0.003625 sa=0 sb=0 sd=0 mult=1 m=1
XM_TSPR TS_REF BIASP VIN VIN sky130_fd_pr__pfet_g5v0d10v5 L=1 W=7 nf=1 ad=2.03 as=2.03 pd=14.58 ps=14.58 nrd=0.0414285714285714
+ nrs=0.0414285714285714 sa=0 sb=0 sd=0 mult=1 m=1
XM_TSR1 TS_REF TS_REF AMP_ENN 0 sky130_fd_pr__nfet_g5v0d10v5 L=2 W=0.42 nf=1 ad=0.1218 as=0.1218 pd=1.42 ps=1.42
+ nrd=0.69047619047619 nrs=0.69047619047619 sa=0 sb=0 sd=0 mult=1 m=1
xcmp VIN EN NB AMP_ENN TS_SNS TS_REF TS_CMP thermal_cmp_regen
XM_TSHUT EA_STUB TS_CMP VIN VIN sky130_fd_pr__pfet_g5v0d10v5 L=0.5 W=20 nf=4 ad=2.9 as=4.35 pd=21.16 ps=31.74 nrd=0.0145
+ nrs=0.0145 sa=0 sb=0 sd=0 mult=1 m=1
R_EASTUB EA_STUB EA_REF 100k m=1
VEAREF EA_REF 0 2.4
.save i(vearef)
**.ends

* expanding   symbol:  design/thermal_cmp_regen.sym # of pins=7
** sym_path: design/thermal_cmp_regen.sym
** sch_path: design/thermal_cmp_regen.sch
.subckt thermal_cmp_regen VIN EN NB AMP_ENN TS_SNS TS_REF TS_CMP
*.ipin VIN
*.ipin EN
*.ipin NB
*.ipin AMP_ENN
*.ipin TS_SNS
*.ipin TS_REF
*.opin TS_CMP
XM_RCTAIL RC_TAIL NB AMP_ENN 0 sky130_fd_pr__nfet_g5v0d10v5 L=1 W=1 nf=1 ad=0.29 as=0.29 pd=2.58 ps=2.58 nrd=0.29 nrs=0.29 sa=0
+ sb=0 sd=0 mult=1 m=1
XM_RCN1 RC_A TS_SNS RC_TAIL 0 sky130_fd_pr__nfet_g5v0d10v5 L=2 W=10 nf=2 ad=1.45 as=2.9 pd=10.58 ps=21.16 nrd=0.029 nrs=0.029 sa=0
+ sb=0 sd=0 mult=1 m=1
XM_RCN2 RC_B TS_REF RC_TAIL 0 sky130_fd_pr__nfet_g5v0d10v5 L=2 W=10 nf=2 ad=1.45 as=2.9 pd=10.58 ps=21.16 nrd=0.029 nrs=0.029 sa=0
+ sb=0 sd=0 mult=1 m=1
XM_RCD1 RC_A RC_A VIN VIN sky130_fd_pr__pfet_g5v0d10v5 L=2 W=10 nf=2 ad=1.45 as=2.9 pd=10.58 ps=21.16 nrd=0.029 nrs=0.029 sa=0
+ sb=0 sd=0 mult=1 m=1
XM_RCD2 RC_B RC_B VIN VIN sky130_fd_pr__pfet_g5v0d10v5 L=2 W=10 nf=2 ad=1.45 as=2.9 pd=10.58 ps=21.16 nrd=0.029 nrs=0.029 sa=0
+ sb=0 sd=0 mult=1 m=1
XM_RCC1 RC_A RC_B VIN VIN sky130_fd_pr__pfet_g5v0d10v5 L=2 W=17 nf=2 ad=2.465 as=4.93 pd=17.58 ps=35.16 nrd=0.0170588235294118
+ nrs=0.0170588235294118 sa=0 sb=0 sd=0 mult=1 m=1
XM_RCC2 RC_B RC_A VIN VIN sky130_fd_pr__pfet_g5v0d10v5 L=2 W=17 nf=2 ad=2.465 as=4.93 pd=17.58 ps=35.16 nrd=0.0170588235294118
+ nrs=0.0170588235294118 sa=0 sb=0 sd=0 mult=1 m=1
XM_RCEA RC_A EN VIN VIN sky130_fd_pr__pfet_g5v0d10v5 L=0.5 W=2 nf=1 ad=0.58 as=0.58 pd=4.58 ps=4.58 nrd=0.145 nrs=0.145 sa=0 sb=0
+ sd=0 mult=1 m=1
XM_RCEB RC_B EN VIN VIN sky130_fd_pr__pfet_g5v0d10v5 L=0.5 W=2 nf=1 ad=0.58 as=0.58 pd=4.58 ps=4.58 nrd=0.145 nrs=0.145 sa=0 sb=0
+ sd=0 mult=1 m=1
XM_RCOP TS_CMP RC_A VIN VIN sky130_fd_pr__pfet_g5v0d10v5 L=1 W=2 nf=1 ad=0.58 as=0.58 pd=4.58 ps=4.58 nrd=0.145 nrs=0.145 sa=0
+ sb=0 sd=0 mult=1 m=1
XM_RCOS TS_CMP NB AMP_ENN 0 sky130_fd_pr__nfet_g5v0d10v5 L=2 W=0.5 nf=1 ad=0.145 as=0.145 pd=1.58 ps=1.58 nrd=0.58 nrs=0.58 sa=0
+ sb=0 sd=0 mult=1 m=1
XM_RCEO TS_CMP EN VIN VIN sky130_fd_pr__pfet_g5v0d10v5 L=0.5 W=2 nf=1 ad=0.58 as=0.58 pd=4.58 ps=4.58 nrd=0.145 nrs=0.145 sa=0
+ sb=0 sd=0 mult=1 m=1
.ends
