* loop-gain corner deck -- generated by sim/bin/corner-run.py, do not edit
* corner: tt_27c_3.30v
.param vsup=3.3
.option wnflag=1
.temp 27
.lib "/home/ubuntu/.volare/sky130A/libs.tech/combined/sky130.lib.spice" tt
** sch_path: sim/loop-gain/testbench/tb_loop_gain.sch
**.subckt tb_loop_gain
VVIN VIN 0 'vsup'
.save i(vvin)
VEN EN 0 'vsup'
.save i(ven)
VVREF VREF 0 DC 1.2 AC 1
.save i(vvref)
xldo VOUT VREF EN VIN ldo_3v3in_1v8out
COUT VOUT VESR 0.33u m=1
VESRSENSE VESR VESRS 0
HESR VESRS 0 VESRSENSE 10m
RLOAD VOUT 0 36 m=1
**** begin user architecture code

.nodeset v(VOUT)=1.8 v(xldo.FB)=1.2 v(xldo.N_FBB)=0.6

**** end user architecture code
**.ends

* expanding   symbol:  design/ldo_3v3in_1v8out.sym # of pins=4
** sym_path: design/ldo_3v3in_1v8out.sym
** sch_path: design/ldo_3v3in_1v8out.sch
.subckt ldo_3v3in_1v8out VOUT VREF EN VIN
*.ipin VIN
*.ipin EN
*.ipin VREF
*.opin VOUT
XR_BIAS VIN NB 0 sky130_fd_pr__res_high_po W=0.42 L=1500 mult=1 m=1
XM_BIASN1 NB NB BIAS_ENN 0 sky130_fd_pr__nfet_g5v0d10v5 L=1 W=4 nf=1 ad=1.16 as=1.16 pd=8.58 ps=8.58 nrd=0.0725 nrs=0.0725 sa=0
+ sb=0 sd=0 mult=1 m=1
XM_ENN BIAS_ENN EN 0 0 sky130_fd_pr__nfet_g5v0d10v5 L=0.5 W=10 nf=1 ad=2.9 as=2.9 pd=20.58 ps=20.58 nrd=0.029 nrs=0.029 sa=0 sb=0
+ sd=0 mult=1 m=1
XM_BIASN2 BIASP NB BIAS_ENN 0 sky130_fd_pr__nfet_g5v0d10v5 L=1 W=4 nf=1 ad=1.16 as=1.16 pd=8.58 ps=8.58 nrd=0.0725 nrs=0.0725 sa=0
+ sb=0 sd=0 mult=1 m=1
XM_BIASP1 BIASP BIASP VIN VIN sky130_fd_pr__pfet_g5v0d10v5 L=1 W=10 nf=2 ad=1.45 as=2.9 pd=10.58 ps=21.16 nrd=0.029 nrs=0.029 sa=0
+ sb=0 sd=0 mult=1 m=1
XM_ENP2 BIASP EN VIN VIN sky130_fd_pr__pfet_g5v0d10v5 L=0.5 W=10 nf=1 ad=2.9 as=2.9 pd=20.58 ps=20.58 nrd=0.029 nrs=0.029 sa=0
+ sb=0 sd=0 mult=1 m=1
XM_TAIL EA_TAIL BIASP VIN VIN sky130_fd_pr__pfet_g5v0d10v5 L=2 W=40 nf=8 ad=5.8 as=7.25 pd=42.32 ps=52.9 nrd=0.00725 nrs=0.00725
+ sa=0 sb=0 sd=0 mult=1 m=1
XM_IN1 EA_D1 FB EA_TAIL VIN sky130_fd_pr__pfet_g5v0d10v5 L=2 W=10 nf=2 ad=1.45 as=2.9 pd=10.58 ps=21.16 nrd=0.029 nrs=0.029 sa=0
+ sb=0 sd=0 mult=1 m=1
XM_IN2 EA_D2 VREF EA_TAIL VIN sky130_fd_pr__pfet_g5v0d10v5 L=2 W=10 nf=2 ad=1.45 as=2.9 pd=10.58 ps=21.16 nrd=0.029 nrs=0.029 sa=0
+ sb=0 sd=0 mult=1 m=1
XM_MIR1 EA_D1 EA_D1 AMP_ENN 0 sky130_fd_pr__nfet_g5v0d10v5 L=4 W=10 nf=2 ad=1.45 as=2.9 pd=10.58 ps=21.16 nrd=0.029 nrs=0.029 sa=0
+ sb=0 sd=0 mult=1 m=1
XM_MIR2 EA_OUT EA_D1 AMP_ENN 0 sky130_fd_pr__nfet_g5v0d10v5 L=4 W=10 nf=2 ad=1.45 as=2.9 pd=10.58 ps=21.16 nrd=0.029 nrs=0.029
+ sa=0 sb=0 sd=0 mult=1 m=1
XM_ENN2 AMP_ENN EN 0 0 sky130_fd_pr__nfet_g5v0d10v5 L=0.5 W=10 nf=1 ad=2.9 as=2.9 pd=20.58 ps=20.58 nrd=0.029 nrs=0.029 sa=0 sb=0
+ sd=0 mult=1 m=1
XM_ENP EA_OUT EN VIN VIN sky130_fd_pr__pfet_g5v0d10v5 L=0.5 W=10 nf=1 ad=2.9 as=2.9 pd=20.58 ps=20.58 nrd=0.029 nrs=0.029 sa=0
+ sb=0 sd=0 mult=1 m=1
XM_MIR3 EA_D2 EA_D2 AMP_ENN 0 sky130_fd_pr__nfet_g5v0d10v5 L=4 W=10 nf=2 ad=1.45 as=2.9 pd=10.58 ps=21.16 nrd=0.029 nrs=0.029 sa=0
+ sb=0 sd=0 mult=1 m=1
XM_MIR4 PB EA_D2 AMP_ENN 0 sky130_fd_pr__nfet_g5v0d10v5 L=4 W=10 nf=2 ad=1.45 as=2.9 pd=10.58 ps=21.16 nrd=0.029 nrs=0.029 sa=0
+ sb=0 sd=0 mult=1 m=1
XM_MIRP1 PB PB VIN VIN sky130_fd_pr__pfet_g5v0d10v5 L=4 W=20 nf=4 ad=2.9 as=4.35 pd=21.16 ps=31.74 nrd=0.0145 nrs=0.0145 sa=0 sb=0
+ sd=0 mult=1 m=1
XM_MIRP2 EA_OUT PB VIN VIN sky130_fd_pr__pfet_g5v0d10v5 L=4 W=20 nf=4 ad=2.9 as=4.35 pd=21.16 ps=31.74 nrd=0.0145 nrs=0.0145 sa=0
+ sb=0 sd=0 mult=1 m=1
XM_ENP5 PB EN VIN VIN sky130_fd_pr__pfet_g5v0d10v5 L=0.5 W=2 nf=1 ad=0.58 as=0.58 pd=4.58 ps=4.58 nrd=0.145 nrs=0.145 sa=0 sb=0
+ sd=0 mult=1 m=1
XM_PASS VOUT EA_OUT VIN VIN sky130_fd_pr__pfet_g5v0d10v5 L=0.5 W=100 nf=25 ad=15.08 as=15.08 pd=111.54 ps=111.54 nrd=0.0029
+ nrs=0.0029 sa=0 sb=0 sd=0 mult=50 m=50
C_COMP VOUT EA_CZ 150p m=1
XR_CZ EA_CZ EA_OUT 0 sky130_fd_pr__res_xhigh_po W=0.42 L=832 mult=1 m=1
XR_FB_A VOUT FB 0 sky130_fd_pr__res_xhigh_po W=0.42 L=180 mult=1 m=1
XR_FB_B FB N_FBB 0 sky130_fd_pr__res_xhigh_po W=0.42 L=180 mult=1 m=1
XR_FB_C N_FBB 0 0 sky130_fd_pr__res_xhigh_po W=0.42 L=180 mult=1 m=1
XM_SENSE CL_SNS EA_OUT VIN VIN sky130_fd_pr__pfet_g5v0d10v5 L=0.5 W=0.42 nf=1 ad=0.1218 as=0.1218 pd=1.42 ps=1.42
+ nrd=0.69047619047619 nrs=0.69047619047619 sa=0 sb=0 sd=0 mult=2 m=2
XM_CLN1 CL_SNS CL_SNS AMP_ENN 0 sky130_fd_pr__nfet_g5v0d10v5 L=1 W=20 nf=1 ad=5.8 as=5.8 pd=40.58 ps=40.58 nrd=0.0145 nrs=0.0145
+ sa=0 sb=0 sd=0 mult=1 m=1
XM_CLN2 CL_CMP CL_SNS AMP_ENN 0 sky130_fd_pr__nfet_g5v0d10v5 L=1 W=1.6 nf=1 ad=0.464 as=0.464 pd=3.78 ps=3.78 nrd=0.18125
+ nrs=0.18125 sa=0 sb=0 sd=0 mult=1 m=1
XM_CLP CL_CMP BIASP VIN VIN sky130_fd_pr__pfet_g5v0d10v5 L=1 W=10 nf=2 ad=1.45 as=2.9 pd=10.58 ps=21.16 nrd=0.029 nrs=0.029 sa=0
+ sb=0 sd=0 mult=1 m=1
XM_CLIM EA_OUT CL_CMP VIN VIN sky130_fd_pr__pfet_g5v0d10v5 L=0.5 W=20 nf=4 ad=2.9 as=4.35 pd=21.16 ps=31.74 nrd=0.0145 nrs=0.0145
+ sa=0 sb=0 sd=0 mult=1 m=1
XM_ENP3 CL_CMP EN VIN VIN sky130_fd_pr__pfet_g5v0d10v5 L=0.5 W=2 nf=1 ad=0.58 as=0.58 pd=4.58 ps=4.58 nrd=0.145 nrs=0.145 sa=0
+ sb=0 sd=0 mult=1 m=1
C_CL VIN CL_CMP 1p m=1
XM_INVP ENB EN VIN VIN sky130_fd_pr__pfet_g5v0d10v5 L=0.5 W=2 nf=1 ad=0.58 as=0.58 pd=4.58 ps=4.58 nrd=0.145 nrs=0.145 sa=0 sb=0
+ sd=0 mult=1 m=1
XM_INVN ENB EN 0 0 sky130_fd_pr__nfet_g5v0d10v5 L=0.5 W=1 nf=1 ad=0.29 as=0.29 pd=2.58 ps=2.58 nrd=0.29 nrs=0.29 sa=0 sb=0 sd=0
+ mult=1 m=1
XM_SSDIS SS ENB 0 0 sky130_fd_pr__nfet_g5v0d10v5 L=0.5 W=2 nf=1 ad=0.58 as=0.58 pd=4.58 ps=4.58 nrd=0.145 nrs=0.145 sa=0 sb=0 sd=0
+ mult=1 m=1
XM_SSCHG SS BIASP VIN VIN sky130_fd_pr__pfet_g5v0d10v5 L=8 W=1 nf=1 ad=0.29 as=0.29 pd=2.58 ps=2.58 nrd=0.29 nrs=0.29 sa=0 sb=0
+ sd=0 mult=1 m=1
C_SS SS 0 10p m=1
XM_IN2S EA_D2 SS EA_TAIL VIN sky130_fd_pr__pfet_g5v0d10v5 L=2 W=10 nf=2 ad=1.45 as=2.9 pd=10.58 ps=21.16 nrd=0.029 nrs=0.029 sa=0
+ sb=0 sd=0 mult=1 m=1
XM_TSPS TS_SNS BIASP VIN VIN sky130_fd_pr__pfet_g5v0d10v5 L=1 W=1.25 nf=1 ad=0.3625 as=0.3625 pd=3.08 ps=3.08 nrd=0.232 nrs=0.232
+ sa=0 sb=0 sd=0 mult=1 m=1
XM_TSD1 TS_SNS TS_SNS TS_MID 0 sky130_fd_pr__nfet_g5v0d10v5 L=4 W=80 nf=16 ad=11.6 as=13.05 pd=84.64 ps=95.22 nrd=0.003625
+ nrs=0.003625 sa=0 sb=0 sd=0 mult=1 m=1
XM_TSD2 TS_MID TS_MID AMP_ENN 0 sky130_fd_pr__nfet_g5v0d10v5 L=4 W=80 nf=16 ad=11.6 as=13.05 pd=84.64 ps=95.22 nrd=0.003625
+ nrs=0.003625 sa=0 sb=0 sd=0 mult=1 m=1
XM_TSPR TS_REF BIASP VIN VIN sky130_fd_pr__pfet_g5v0d10v5 L=1 W=7 nf=1 ad=2.03 as=2.03 pd=14.58 ps=14.58 nrd=0.0414285714285714
+ nrs=0.0414285714285714 sa=0 sb=0 sd=0 mult=1 m=1
XM_TSR1 TS_REF TS_REF AMP_ENN 0 sky130_fd_pr__nfet_g5v0d10v5 L=2 W=0.42 nf=1 ad=0.1218 as=0.1218 pd=1.42 ps=1.42
+ nrd=0.69047619047619 nrs=0.69047619047619 sa=0 sb=0 sd=0 mult=1 m=1
XM_TSHUT EA_OUT TS_CMP VIN VIN sky130_fd_pr__pfet_g5v0d10v5 L=0.5 W=20 nf=4 ad=2.9 as=4.35 pd=21.16 ps=31.74 nrd=0.0145 nrs=0.0145
+ sa=0 sb=0 sd=0 mult=1 m=1
XM_ENP4 TS_CMP EN VIN VIN sky130_fd_pr__pfet_g5v0d10v5 L=0.5 W=2 nf=1 ad=0.58 as=0.58 pd=4.58 ps=4.58 nrd=0.145 nrs=0.145 sa=0
+ sb=0 sd=0 mult=1 m=1
C_TS VIN TS_CMP 1p m=1
XM_RCTAIL RC_TAIL NB AMP_ENN 0 sky130_fd_pr__nfet_g5v0d10v5 L=1 W=1 nf=1 ad=0.29 as=0.29 pd=2.58 ps=2.58 nrd=0.29 nrs=0.29 sa=0
+ sb=0 sd=0 mult=1 m=1
XM_RCN1 RC_A TS_SNS RC_TAIL 0 sky130_fd_pr__nfet_g5v0d10v5 L=2 W=10 nf=2 ad=1.45 as=2.9 pd=10.58 ps=21.16 nrd=0.029 nrs=0.029 sa=0
+ sb=0 sd=0 mult=1 m=1
XM_RCN2 RC_B TS_REF RC_TAIL 0 sky130_fd_pr__nfet_g5v0d10v5 L=2 W=10 nf=2 ad=1.45 as=2.9 pd=10.58 ps=21.16 nrd=0.029 nrs=0.029 sa=0
+ sb=0 sd=0 mult=1 m=1
XM_RCD1 RC_A RC_A VIN VIN sky130_fd_pr__pfet_g5v0d10v5 L=2 W=10 nf=2 ad=1.45 as=2.9 pd=10.58 ps=21.16 nrd=0.029 nrs=0.029 sa=0
+ sb=0 sd=0 mult=1 m=1
XM_RCD2 RC_B RC_B VIN VIN sky130_fd_pr__pfet_g5v0d10v5 L=2 W=10 nf=2 ad=1.45 as=2.9 pd=10.58 ps=21.16 nrd=0.029 nrs=0.029 sa=0
+ sb=0 sd=0 mult=1 m=1
XM_RCC1 RC_A RC_B VIN VIN sky130_fd_pr__pfet_g5v0d10v5 L=2 W=17 nf=2 ad=2.465 as=4.93 pd=17.58 ps=35.16 nrd=0.0170588235294118
+ nrs=0.0170588235294118 sa=0 sb=0 sd=0 mult=1 m=1
XM_RCC2 RC_B RC_A VIN VIN sky130_fd_pr__pfet_g5v0d10v5 L=2 W=17 nf=2 ad=2.465 as=4.93 pd=17.58 ps=35.16 nrd=0.0170588235294118
+ nrs=0.0170588235294118 sa=0 sb=0 sd=0 mult=1 m=1
XM_RCEA RC_A EN VIN VIN sky130_fd_pr__pfet_g5v0d10v5 L=0.5 W=2 nf=1 ad=0.58 as=0.58 pd=4.58 ps=4.58 nrd=0.145 nrs=0.145 sa=0 sb=0
+ sd=0 mult=1 m=1
XM_RCEB RC_B EN VIN VIN sky130_fd_pr__pfet_g5v0d10v5 L=0.5 W=2 nf=1 ad=0.58 as=0.58 pd=4.58 ps=4.58 nrd=0.145 nrs=0.145 sa=0 sb=0
+ sd=0 mult=1 m=1
XM_RCOP TS_CMP RC_A VIN VIN sky130_fd_pr__pfet_g5v0d10v5 L=1 W=2 nf=1 ad=0.58 as=0.58 pd=4.58 ps=4.58 nrd=0.145 nrs=0.145 sa=0
+ sb=0 sd=0 mult=1 m=1
XM_RCOS TS_CMP NB AMP_ENN 0 sky130_fd_pr__nfet_g5v0d10v5 L=2 W=0.5 nf=1 ad=0.145 as=0.145 pd=1.58 ps=1.58 nrd=0.58 nrs=0.58 sa=0
+ sb=0 sd=0 mult=1 m=1
XM_RCEO TS_CMP EN VIN VIN sky130_fd_pr__pfet_g5v0d10v5 L=0.5 W=2 nf=1 ad=0.58 as=0.58 pd=4.58 ps=4.58 nrd=0.145 nrs=0.145 sa=0
+ sb=0 sd=0 mult=1 m=1
.ends

.control
save all
set numdgt=10
set units=degrees
set wr_vecnames
set wr_singlescale
* --- leg 1: 0.33u/10m/0mA ---
alter cout = 3.3e-07
alter hesr gain = 0.01
alter rload = 1e+12
op
let vseed = v(vout)
let ivin = -i(vvin)
echo PT1_OP
print vseed ivin
ac dec 30 1e-2 1e+09
let lg = v(xldo.fb)/(1-v(xldo.fb))
let lgdb = db(lg)
let lgph = cph(lg)
wrdata resp_leg1.txt lg v(xldo.ea_out) v(xldo.ea_cz) v(vout) v(xldo.fb) v(xldo.ea_d1) v(xldo.ea_tail)
meas ac fc when lgdb=0 cross=1
meas ac phc find lgph when lgdb=0 cross=1
meas ac gmdb find lgdb when lgph=-180 cross=1
let dcg = lgdb[0]
echo PT1_AC
print fc
print phc
print gmdb
print dcg
* --- leg 2: 4.7u/10m/0mA ---
alter cout = 4.7e-06
alter hesr gain = 0.01
alter rload = 1e+12
op
let vseed = v(vout)
let ivin = -i(vvin)
echo PT2_OP
print vseed ivin
ac dec 30 1e-2 1e+09
let lg = v(xldo.fb)/(1-v(xldo.fb))
let lgdb = db(lg)
let lgph = cph(lg)
wrdata resp_leg2.txt lg v(xldo.ea_out) v(xldo.ea_cz) v(vout) v(xldo.fb) v(xldo.ea_d1) v(xldo.ea_tail)
meas ac fc when lgdb=0 cross=1
meas ac phc find lgph when lgdb=0 cross=1
meas ac gmdb find lgdb when lgph=-180 cross=1
let dcg = lgdb[0]
echo PT2_AC
print fc
print phc
print gmdb
print dcg
* --- leg 3: 0.33u/0/0mA ---
alter cout = 3.3e-07
alter hesr gain = 0
alter rload = 1e+12
op
let vseed = v(vout)
let ivin = -i(vvin)
echo PT3_OP
print vseed ivin
ac dec 30 1e-2 1e+09
let lg = v(xldo.fb)/(1-v(xldo.fb))
let lgdb = db(lg)
let lgph = cph(lg)
wrdata resp_leg3.txt lg v(xldo.ea_out) v(xldo.ea_cz) v(vout) v(xldo.fb) v(xldo.ea_d1) v(xldo.ea_tail)
meas ac fc when lgdb=0 cross=1
meas ac phc find lgph when lgdb=0 cross=1
meas ac gmdb find lgdb when lgph=-180 cross=1
let dcg = lgdb[0]
echo PT3_AC
print fc
print phc
print gmdb
print dcg
* --- leg 4: 4.7u/0/0mA ---
alter cout = 4.7e-06
alter hesr gain = 0
alter rload = 1e+12
op
let vseed = v(vout)
let ivin = -i(vvin)
echo PT4_OP
print vseed ivin
ac dec 30 1e-2 1e+09
let lg = v(xldo.fb)/(1-v(xldo.fb))
let lgdb = db(lg)
let lgph = cph(lg)
wrdata resp_leg4.txt lg v(xldo.ea_out) v(xldo.ea_cz) v(vout) v(xldo.fb) v(xldo.ea_d1) v(xldo.ea_tail)
meas ac fc when lgdb=0 cross=1
meas ac phc find lgph when lgdb=0 cross=1
meas ac gmdb find lgdb when lgph=-180 cross=1
let dcg = lgdb[0]
echo PT4_AC
print fc
print phc
print gmdb
print dcg
* --- leg 5: 0.33u/500m/0mA ---
alter cout = 3.3e-07
alter hesr gain = 0.5
alter rload = 1e+12
op
let vseed = v(vout)
let ivin = -i(vvin)
echo PT5_OP
print vseed ivin
ac dec 30 1e-2 1e+09
let lg = v(xldo.fb)/(1-v(xldo.fb))
let lgdb = db(lg)
let lgph = cph(lg)
wrdata resp_leg5.txt lg v(xldo.ea_out) v(xldo.ea_cz) v(vout) v(xldo.fb) v(xldo.ea_d1) v(xldo.ea_tail)
meas ac fc when lgdb=0 cross=1
meas ac phc find lgph when lgdb=0 cross=1
meas ac gmdb find lgdb when lgph=-180 cross=1
let dcg = lgdb[0]
echo PT5_AC
print fc
print phc
print gmdb
print dcg
* --- leg 6: 4.7u/500m/0mA ---
alter cout = 4.7e-06
alter hesr gain = 0.5
alter rload = 1e+12
op
let vseed = v(vout)
let ivin = -i(vvin)
echo PT6_OP
print vseed ivin
ac dec 30 1e-2 1e+09
let lg = v(xldo.fb)/(1-v(xldo.fb))
let lgdb = db(lg)
let lgph = cph(lg)
wrdata resp_leg6.txt lg v(xldo.ea_out) v(xldo.ea_cz) v(vout) v(xldo.fb) v(xldo.ea_d1) v(xldo.ea_tail)
meas ac fc when lgdb=0 cross=1
meas ac phc find lgph when lgdb=0 cross=1
meas ac gmdb find lgdb when lgph=-180 cross=1
let dcg = lgdb[0]
echo PT6_AC
print fc
print phc
print gmdb
print dcg
* --- leg 7: 0.33u/10m/1mA ---
alter cout = 3.3e-07
alter hesr gain = 0.01
alter rload = 1800
op
let vseed = v(vout)
let ivin = -i(vvin)
echo PT7_OP
print vseed ivin
ac dec 30 1e-2 1e+09
let lg = v(xldo.fb)/(1-v(xldo.fb))
let lgdb = db(lg)
let lgph = cph(lg)
wrdata resp_leg7.txt lg v(xldo.ea_out) v(xldo.ea_cz) v(vout) v(xldo.fb) v(xldo.ea_d1) v(xldo.ea_tail)
meas ac fc when lgdb=0 cross=1
meas ac phc find lgph when lgdb=0 cross=1
meas ac gmdb find lgdb when lgph=-180 cross=1
let dcg = lgdb[0]
echo PT7_AC
print fc
print phc
print gmdb
print dcg
* --- leg 8: 4.7u/10m/1mA ---
alter cout = 4.7e-06
alter hesr gain = 0.01
alter rload = 1800
op
let vseed = v(vout)
let ivin = -i(vvin)
echo PT8_OP
print vseed ivin
ac dec 30 1e-2 1e+09
let lg = v(xldo.fb)/(1-v(xldo.fb))
let lgdb = db(lg)
let lgph = cph(lg)
wrdata resp_leg8.txt lg v(xldo.ea_out) v(xldo.ea_cz) v(vout) v(xldo.fb) v(xldo.ea_d1) v(xldo.ea_tail)
meas ac fc when lgdb=0 cross=1
meas ac phc find lgph when lgdb=0 cross=1
meas ac gmdb find lgdb when lgph=-180 cross=1
let dcg = lgdb[0]
echo PT8_AC
print fc
print phc
print gmdb
print dcg
* --- leg 9: 0.33u/10m/50mA ---
alter cout = 3.3e-07
alter hesr gain = 0.01
alter rload = 36
op
let vseed = v(vout)
let ivin = -i(vvin)
echo PT9_OP
print vseed ivin
ac dec 30 1e-2 1e+09
let lg = v(xldo.fb)/(1-v(xldo.fb))
let lgdb = db(lg)
let lgph = cph(lg)
wrdata resp_leg9.txt lg v(xldo.ea_out) v(xldo.ea_cz) v(vout) v(xldo.fb) v(xldo.ea_d1) v(xldo.ea_tail)
meas ac fc when lgdb=0 cross=1
meas ac phc find lgph when lgdb=0 cross=1
meas ac gmdb find lgdb when lgph=-180 cross=1
let dcg = lgdb[0]
echo PT9_AC
print fc
print phc
print gmdb
print dcg
* --- leg 10: 4.7u/10m/50mA ---
alter cout = 4.7e-06
alter hesr gain = 0.01
alter rload = 36
op
let vseed = v(vout)
let ivin = -i(vvin)
echo PT10_OP
print vseed ivin
ac dec 30 1e-2 1e+09
let lg = v(xldo.fb)/(1-v(xldo.fb))
let lgdb = db(lg)
let lgph = cph(lg)
wrdata resp_leg10.txt lg v(xldo.ea_out) v(xldo.ea_cz) v(vout) v(xldo.fb) v(xldo.ea_d1) v(xldo.ea_tail)
meas ac fc when lgdb=0 cross=1
meas ac phc find lgph when lgdb=0 cross=1
meas ac gmdb find lgdb when lgph=-180 cross=1
let dcg = lgdb[0]
echo PT10_AC
print fc
print phc
print gmdb
print dcg
quit
.endc
.end
