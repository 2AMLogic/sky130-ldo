* load-transient corner deck -- generated by sim/bin/corner-run.py, do not edit
* corner: tt_27c_3.30v
.param vsup=3.3
.option wnflag=1
.temp 27
.lib "/home/ubuntu/.volare/sky130A/libs.tech/combined/sky130.lib.spice" tt
** sch_path: sim/load-transient/testbench/tb_load_transient.sch
**.subckt tb_load_transient
VVIN VIN 0 'vsup'
.save i(vvin)
VEN EN 0 'vsup'
.save i(ven)
VVREF VREF 0 1.2
.save i(vvref)
xldo VOUT VREF EN VIN ldo_3v3in_1v8out
COUT VOUT VESR 4.7u m=1
RESR VESR 0 10m m=1
CDIR VOUT 0 0 m=1
ILOAD VOUT 0 PULSE(1m 50m 1m 1u 1u 1m 4m)
**** begin user architecture code

.ic v(VOUT)=1.8 v(xldo.FB)=1.2 v(xldo.N_FBB)=0.6 v(xldo.EA_OUT)={vsup-0.909} v(xldo.EA_CZ)={vsup-0.909} v(xldo.SS)={vsup-0.027} v(xldo.BIASP)={vsup-1.064} v(xldo.NB)=0.864

**** end user architecture code
**.ends

* expanding   symbol:  design/ldo_3v3in_1v8out.sym # of pins=4
** sym_path: design/ldo_3v3in_1v8out.sym
** sch_path: design/ldo_3v3in_1v8out.sch
.subckt ldo_3v3in_1v8out VOUT VREF EN VIN
*.ipin VIN
*.ipin EN
*.ipin VREF
*.opin VOUT
XR_BIAS VIN NB 0 sky130_fd_pr__res_high_po W=0.42 L=1500 mult=1 m=1
XM_BIASN1 NB NB BIAS_ENN 0 sky130_fd_pr__nfet_g5v0d10v5 L=1 W=4 nf=1 ad=1.16 as=1.16 pd=8.58 ps=8.58 nrd=0.0725 nrs=0.0725 sa=0
+ sb=0 sd=0 mult=1 m=1
XM_ENN BIAS_ENN EN 0 0 sky130_fd_pr__nfet_g5v0d10v5 L=0.5 W=10 nf=1 ad=2.9 as=2.9 pd=20.58 ps=20.58 nrd=0.029 nrs=0.029 sa=0 sb=0
+ sd=0 mult=1 m=1
XM_BIASN2 BIASP NB BIAS_ENN 0 sky130_fd_pr__nfet_g5v0d10v5 L=1 W=4 nf=1 ad=1.16 as=1.16 pd=8.58 ps=8.58 nrd=0.0725 nrs=0.0725 sa=0
+ sb=0 sd=0 mult=1 m=1
XM_BIASP1 BIASP BIASP VIN VIN sky130_fd_pr__pfet_g5v0d10v5 L=1 W=10 nf=2 ad=1.45 as=2.9 pd=10.58 ps=21.16 nrd=0.029 nrs=0.029 sa=0
+ sb=0 sd=0 mult=1 m=1
XM_ENP2 BIASP EN VIN VIN sky130_fd_pr__pfet_g5v0d10v5 L=0.5 W=10 nf=1 ad=2.9 as=2.9 pd=20.58 ps=20.58 nrd=0.029 nrs=0.029 sa=0
+ sb=0 sd=0 mult=1 m=1
XM_ENN2 AMP_ENN EN 0 0 sky130_fd_pr__nfet_g5v0d10v5 L=0.5 W=10 nf=1 ad=2.9 as=2.9 pd=20.58 ps=20.58 nrd=0.029 nrs=0.029 sa=0 sb=0
+ sd=0 mult=1 m=1
XM_ENP EA_OUT EN VIN VIN sky130_fd_pr__pfet_g5v0d10v5 L=0.5 W=10 nf=1 ad=2.9 as=2.9 pd=20.58 ps=20.58 nrd=0.029 nrs=0.029 sa=0
+ sb=0 sd=0 mult=1 m=1
XM_ENP5 ND1 EN VIN VIN sky130_fd_pr__pfet_g5v0d10v5 L=0.5 W=2 nf=1 ad=0.58 as=0.58 pd=4.58 ps=4.58 nrd=0.145 nrs=0.145 sa=0 sb=0
+ sd=0 mult=1 m=1
XM_PASS VOUT EA_OUT VIN VIN sky130_fd_pr__pfet_g5v0d10v5 L=0.5 W=100 nf=25 ad=15.08 as=15.08 pd=111.54 ps=111.54 nrd=0.0029
+ nrs=0.0029 sa=0 sb=0 sd=0 mult=50 m=50
C_COMP VOUT EA_CZ 150p m=1
XR_CZ EA_CZ EA_OUT 0 sky130_fd_pr__res_xhigh_po W=0.42 L=52 mult=1 m=1
XR_FB_A VOUT FB 0 sky130_fd_pr__res_xhigh_po W=0.42 L=180 mult=1 m=1
XR_FB_B FB N_FBB 0 sky130_fd_pr__res_xhigh_po W=0.42 L=180 mult=1 m=1
XR_FB_C N_FBB 0 0 sky130_fd_pr__res_xhigh_po W=0.42 L=180 mult=1 m=1
XM_SENSE CL_SNS EA_OUT VIN VIN sky130_fd_pr__pfet_g5v0d10v5 L=0.5 W=0.42 nf=1 ad=0.1218 as=0.1218 pd=1.42 ps=1.42
+ nrd=0.69047619047619 nrs=0.69047619047619 sa=0 sb=0 sd=0 mult=2 m=2
XM_CLN1 CL_SNS CL_SNS AMP_ENN 0 sky130_fd_pr__nfet_g5v0d10v5 L=1 W=20 nf=1 ad=5.8 as=5.8 pd=40.58 ps=40.58 nrd=0.0145 nrs=0.0145
+ sa=0 sb=0 sd=0 mult=1 m=1
XM_CLN2 CL_CMP CL_SNS AMP_ENN 0 sky130_fd_pr__nfet_g5v0d10v5 L=1 W=1.6 nf=1 ad=0.464 as=0.464 pd=3.78 ps=3.78 nrd=0.18125
+ nrs=0.18125 sa=0 sb=0 sd=0 mult=1 m=1
XM_CLP CL_CMP PBR VIN VIN sky130_fd_pr__pfet_g5v0d10v5 L=1 W=10 nf=2 ad=1.45 as=2.9 pd=10.58 ps=21.16 nrd=0.029 nrs=0.029 sa=0
+ sb=0 sd=0 mult=1 m=1
XM_CLIM EA_OUT CL_CMP VIN VIN sky130_fd_pr__pfet_g5v0d10v5 L=0.5 W=20 nf=4 ad=2.9 as=4.35 pd=21.16 ps=31.74 nrd=0.0145 nrs=0.0145
+ sa=0 sb=0 sd=0 mult=1 m=1
XM_ENP3 CL_CMP EN VIN VIN sky130_fd_pr__pfet_g5v0d10v5 L=0.5 W=2 nf=1 ad=0.58 as=0.58 pd=4.58 ps=4.58 nrd=0.145 nrs=0.145 sa=0
+ sb=0 sd=0 mult=1 m=1
C_CL VIN CL_CMP 1p m=1
XM_INVP ENB EN VIN VIN sky130_fd_pr__pfet_g5v0d10v5 L=0.5 W=2 nf=1 ad=0.58 as=0.58 pd=4.58 ps=4.58 nrd=0.145 nrs=0.145 sa=0 sb=0
+ sd=0 mult=1 m=1
XM_INVN ENB EN 0 0 sky130_fd_pr__nfet_g5v0d10v5 L=0.5 W=1 nf=1 ad=0.29 as=0.29 pd=2.58 ps=2.58 nrd=0.29 nrs=0.29 sa=0 sb=0 sd=0
+ mult=1 m=1
XM_SSDIS SS ENB 0 0 sky130_fd_pr__nfet_g5v0d10v5 L=0.5 W=2 nf=1 ad=0.58 as=0.58 pd=4.58 ps=4.58 nrd=0.145 nrs=0.145 sa=0 sb=0 sd=0
+ mult=1 m=1
XM_SSCHG SS BIASP VIN VIN sky130_fd_pr__pfet_g5v0d10v5 L=8 W=1 nf=1 ad=0.29 as=0.29 pd=2.58 ps=2.58 nrd=0.29 nrs=0.29 sa=0 sb=0
+ sd=0 mult=1 m=1
C_SS SS 0 10p m=1
XM_TSPS TS_SNS BIASP VIN VIN sky130_fd_pr__pfet_g5v0d10v5 L=1 W=1.25 nf=1 ad=0.3625 as=0.3625 pd=3.08 ps=3.08 nrd=0.232 nrs=0.232
+ sa=0 sb=0 sd=0 mult=1 m=1
XM_TSD1 TS_SNS TS_SNS TS_MID 0 sky130_fd_pr__nfet_g5v0d10v5 L=4 W=80 nf=16 ad=11.6 as=13.05 pd=84.64 ps=95.22 nrd=0.003625
+ nrs=0.003625 sa=0 sb=0 sd=0 mult=1 m=1
XM_TSD2 TS_MID TS_MID AMP_ENN 0 sky130_fd_pr__nfet_g5v0d10v5 L=4 W=80 nf=16 ad=11.6 as=13.05 pd=84.64 ps=95.22 nrd=0.003625
+ nrs=0.003625 sa=0 sb=0 sd=0 mult=1 m=1
XM_TSPR TS_REF BIASP VIN VIN sky130_fd_pr__pfet_g5v0d10v5 L=1 W=7 nf=1 ad=2.03 as=2.03 pd=14.58 ps=14.58 nrd=0.0414285714285714
+ nrs=0.0414285714285714 sa=0 sb=0 sd=0 mult=1 m=1
XM_TSR1 TS_REF TS_REF AMP_ENN 0 sky130_fd_pr__nfet_g5v0d10v5 L=2 W=0.42 nf=1 ad=0.1218 as=0.1218 pd=1.42 ps=1.42
+ nrd=0.69047619047619 nrs=0.69047619047619 sa=0 sb=0 sd=0 mult=1 m=1
XM_TSHUT EA_OUT TS_CMP VIN VIN sky130_fd_pr__pfet_g5v0d10v5 L=0.5 W=20 nf=4 ad=2.9 as=4.35 pd=21.16 ps=31.74 nrd=0.0145 nrs=0.0145
+ sa=0 sb=0 sd=0 mult=1 m=1
XM_ENP4 TS_CMP EN VIN VIN sky130_fd_pr__pfet_g5v0d10v5 L=0.5 W=2 nf=1 ad=0.58 as=0.58 pd=4.58 ps=4.58 nrd=0.145 nrs=0.145 sa=0
+ sb=0 sd=0 mult=1 m=1
C_TS VIN TS_CMP 1p m=1
XM_RCTAIL RC_TAIL NB AMP_ENN 0 sky130_fd_pr__nfet_g5v0d10v5 L=1 W=1 nf=1 ad=0.29 as=0.29 pd=2.58 ps=2.58 nrd=0.29 nrs=0.29 sa=0
+ sb=0 sd=0 mult=1 m=1
XM_RCN1 RC_A TS_SNS RC_TAIL 0 sky130_fd_pr__nfet_g5v0d10v5 L=2 W=10 nf=2 ad=1.45 as=2.9 pd=10.58 ps=21.16 nrd=0.029 nrs=0.029 sa=0
+ sb=0 sd=0 mult=1 m=1
XM_RCN2 RC_B TS_REF RC_TAIL 0 sky130_fd_pr__nfet_g5v0d10v5 L=2 W=10 nf=2 ad=1.45 as=2.9 pd=10.58 ps=21.16 nrd=0.029 nrs=0.029 sa=0
+ sb=0 sd=0 mult=1 m=1
XM_RCD1 RC_A RC_A VIN VIN sky130_fd_pr__pfet_g5v0d10v5 L=2 W=10 nf=2 ad=1.45 as=2.9 pd=10.58 ps=21.16 nrd=0.029 nrs=0.029 sa=0
+ sb=0 sd=0 mult=1 m=1
XM_RCD2 RC_B RC_B VIN VIN sky130_fd_pr__pfet_g5v0d10v5 L=2 W=10 nf=2 ad=1.45 as=2.9 pd=10.58 ps=21.16 nrd=0.029 nrs=0.029 sa=0
+ sb=0 sd=0 mult=1 m=1
XM_RCC1 RC_A RC_B VIN VIN sky130_fd_pr__pfet_g5v0d10v5 L=2 W=17 nf=2 ad=2.465 as=4.93 pd=17.58 ps=35.16 nrd=0.0170588235294118
+ nrs=0.0170588235294118 sa=0 sb=0 sd=0 mult=1 m=1
XM_RCC2 RC_B RC_A VIN VIN sky130_fd_pr__pfet_g5v0d10v5 L=2 W=17 nf=2 ad=2.465 as=4.93 pd=17.58 ps=35.16 nrd=0.0170588235294118
+ nrs=0.0170588235294118 sa=0 sb=0 sd=0 mult=1 m=1
XM_RCEA RC_A EN VIN VIN sky130_fd_pr__pfet_g5v0d10v5 L=0.5 W=2 nf=1 ad=0.58 as=0.58 pd=4.58 ps=4.58 nrd=0.145 nrs=0.145 sa=0 sb=0
+ sd=0 mult=1 m=1
XM_RCEB RC_B EN VIN VIN sky130_fd_pr__pfet_g5v0d10v5 L=0.5 W=2 nf=1 ad=0.58 as=0.58 pd=4.58 ps=4.58 nrd=0.145 nrs=0.145 sa=0 sb=0
+ sd=0 mult=1 m=1
XM_RCOP TS_CMP RC_A VIN VIN sky130_fd_pr__pfet_g5v0d10v5 L=1 W=2 nf=1 ad=0.58 as=0.58 pd=4.58 ps=4.58 nrd=0.145 nrs=0.145 sa=0
+ sb=0 sd=0 mult=1 m=1
XM_RCOS TS_CMP NB AMP_ENN 0 sky130_fd_pr__nfet_g5v0d10v5 L=2 W=0.5 nf=1 ad=0.145 as=0.145 pd=1.58 ps=1.58 nrd=0.58 nrs=0.58 sa=0
+ sb=0 sd=0 mult=1 m=1
XM_RCEO TS_CMP EN VIN VIN sky130_fd_pr__pfet_g5v0d10v5 L=0.5 W=2 nf=1 ad=0.58 as=0.58 pd=4.58 ps=4.58 nrd=0.145 nrs=0.145 sa=0
+ sb=0 sd=0 mult=1 m=1
* --- issue #357 candidate rev2: VREF-referenced bias + NMOS-input OTA (diagnostic) ---
XM_VRF PBR VREF NVR 0 sky130_fd_pr__nfet_g5v0d10v5 L=1 W=10 nf=2 ad=1.45
+ as=2.9 pd=10.58 ps=21.16
+ nrd=0.029 nrs=0.029 sa=0 sb=0 sd=0 mult=1 m=1
XR_VR NVR AMP_ENN 0 sky130_fd_pr__res_high_po W=0.42 L=550 mult=1 m=1
XM_PBR PBR PBR VIN VIN sky130_fd_pr__pfet_g5v0d10v5 L=1 W=2.5 nf=1 ad=0.725
+ as=0.725 pd=5.58 ps=5.58
+ nrd=0.116 nrs=0.116 sa=0 sb=0 sd=0 mult=1 m=1
XM_PBN NBR PBR VIN VIN sky130_fd_pr__pfet_g5v0d10v5 L=1 W=1.75 nf=1 ad=0.5075
+ as=0.5075 pd=4.08 ps=4.08
+ nrd=0.165714 nrs=0.165714 sa=0 sb=0 sd=0 mult=1 m=1
XM_NBR NBR NBR AMP_ENN 0 sky130_fd_pr__nfet_g5v0d10v5 L=2 W=2.5 nf=1 ad=0.725
+ as=0.725 pd=5.58 ps=5.58
+ nrd=0.116 nrs=0.116 sa=0 sb=0 sd=0 mult=1 m=1
XM_NTAIL NTAIL NBR AMP_ENN 0 sky130_fd_pr__nfet_g5v0d10v5 L=2 W=7 nf=2 ad=1.015
+ as=2.03 pd=7.58 ps=15.16
+ nrd=0.0414286 nrs=0.0414286 sa=0 sb=0 sd=0 mult=1 m=1
XM_NIN1 NX1 FB NTAIL 0 sky130_fd_pr__nfet_g5v0d10v5 L=2 W=10 nf=2 ad=1.45
+ as=2.9 pd=10.58 ps=21.16
+ nrd=0.029 nrs=0.029 sa=0 sb=0 sd=0 mult=1 m=1
XM_NIN1C ND1 VIN NX1 0 sky130_fd_pr__nfet_g5v0d10v5 L=1 W=10 nf=2 ad=1.45
+ as=2.9 pd=10.58 ps=21.16
+ nrd=0.029 nrs=0.029 sa=0 sb=0 sd=0 mult=1 m=1
XM_NIN2 NX2 VREF NTAIL 0 sky130_fd_pr__nfet_g5v0d10v5 L=2 W=10 nf=2 ad=1.45
+ as=2.9 pd=10.58 ps=21.16
+ nrd=0.029 nrs=0.029 sa=0 sb=0 sd=0 mult=1 m=1
XM_NIN2S ND2 SS NX2 0 sky130_fd_pr__nfet_g5v0d10v5 L=1 W=10 nf=2 ad=1.45
+ as=2.9 pd=10.58 ps=21.16
+ nrd=0.029 nrs=0.029 sa=0 sb=0 sd=0 mult=1 m=1
XM_PD1 ND1 ND1 VIN VIN sky130_fd_pr__pfet_g5v0d10v5 L=4 W=20 nf=4 ad=2.9
+ as=4.35 pd=21.16 ps=31.74
+ nrd=0.0145 nrs=0.0145 sa=0 sb=0 sd=0 mult=1 m=1
XM_PO1 EA_OUT ND1 VIN VIN sky130_fd_pr__pfet_g5v0d10v5 L=4 W=20 nf=4 ad=2.9
+ as=4.35 pd=21.16 ps=31.74
+ nrd=0.0145 nrs=0.0145 sa=0 sb=0 sd=0 mult=1 m=1
XM_PD2 ND2 ND2 VIN VIN sky130_fd_pr__pfet_g5v0d10v5 L=4 W=20 nf=4 ad=2.9
+ as=4.35 pd=21.16 ps=31.74
+ nrd=0.0145 nrs=0.0145 sa=0 sb=0 sd=0 mult=1 m=1
XM_PO2 NM ND2 VIN VIN sky130_fd_pr__pfet_g5v0d10v5 L=4 W=20 nf=4 ad=2.9
+ as=4.35 pd=21.16 ps=31.74
+ nrd=0.0145 nrs=0.0145 sa=0 sb=0 sd=0 mult=1 m=1
XM_NMD NM NM AMP_ENN 0 sky130_fd_pr__nfet_g5v0d10v5 L=4 W=10 nf=2 ad=1.45
+ as=2.9 pd=10.58 ps=21.16
+ nrd=0.029 nrs=0.029 sa=0 sb=0 sd=0 mult=1 m=1
XM_NMO EA_OUT NM AMP_ENN 0 sky130_fd_pr__nfet_g5v0d10v5 L=4 W=10 nf=2 ad=1.45
+ as=2.9 pd=10.58 ps=21.16
+ nrd=0.029 nrs=0.029 sa=0 sb=0 sd=0 mult=1 m=1
XM_ENP6 PBR EN VIN VIN sky130_fd_pr__pfet_g5v0d10v5 L=0.5 W=2 nf=1 ad=0.58
+ as=0.58 pd=4.58 ps=4.58
+ nrd=0.145 nrs=0.145 sa=0 sb=0 sd=0 mult=1 m=1
XM_ENP7 ND2 EN VIN VIN sky130_fd_pr__pfet_g5v0d10v5 L=0.5 W=2 nf=1 ad=0.58
+ as=0.58 pd=4.58 ps=4.58
+ nrd=0.145 nrs=0.145 sa=0 sb=0 sd=0 mult=1 m=1
.ends

.control
save all
* --- initial-condition contract (issue #171), applied by issue #180 ---
* This `tran` deliberately carries NO `uic`: the transient is released from
* an operating-point solve that testbench/tb_load_transient.sch's IC_SEED
* `.ic` card constrains to the loop's intended regulating branch at the
* pre-step 1 mA load. That is #164's variant-B shape (PR #170), the second of
* the two shapes sim/README.md's "Initial-condition contract (issue #171)"
* accepts, and the shape sim/ic-screen-125c-b uses. It was chosen over `uic`
* + an EN-edge preamble because this bench steps the LOAD at an already-
* regulating condition: an EN preamble would shift every timestamp below AND
* make C_OUT's pre-step charge state depend on the soft-start ramp, which
* #119's charge-limited peak-excursion finding (see this manifest's claim)
* requires be held fixed. The step edges (1.000ms / 2.001ms) and the 3ms span
* are therefore unchanged from the superseded 20260825-081255-4cb27f8 record.
* --- window grid (issue #313) ---
* The tran and every .meas/let for this bench live in `window_grid.leg_analyses`,
* which corner-run.py instantiates once per declared COUT/ESR leg (reset, alter,
* tran, measure -- see window_grid.reset_policy). Reference levels, windows and
* the outband/w_rise/w_fall recovery vectors are the #180/#119 definitions, now
* evaluated per leg; the rise/fall peak windows split the old joint 1.000m-2.999m
* search at the fall edge (2.001m) so each step direction is its own result.
* --- window leg c330n_esr0: COUT=3.3e-07 F, ESR=0 ohm (independent reset/seed/tran) ---
reset
save all
alter cout = 0.0
alter resr = 0.01
alter cdir = 3.3e-07
tran 200n 3m
meas tran v_pre AVG v(vout) FROM=0.800m TO=0.999m
meas tran v_rise_min MIN v(vout) FROM=1.000m TO=2.001m
meas tran v_rise_max MAX v(vout) FROM=1.000m TO=2.001m
meas tran v_fall_min MIN v(vout) FROM=2.001m TO=2.999m
meas tran v_fall_max MAX v(vout) FROM=2.001m TO=2.999m
meas tran v_50ma FIND v(vout) AT=2.000m
let vpre = v_pre
let dev = abs(v(vout) - vpre)
let band = 0.01 * vpre
let outband = 0.5*(1 + (dev-band)/(abs(dev-band)+1e-18))
let w_rise = 0.5*(1 + (time-1.0m)/(abs(time-1.0m)+1e-18)) * 0.5*(1 + (2.0m-time)/(abs(2.0m-time)+1e-18))
let w_fall = 0.5*(1 + (time-2.001m)/(abs(time-2.001m)+1e-18)) * 0.5*(1 + (2.999m-time)/(abs(2.999m-time)+1e-18))
let meas_vout_pre_v__c330n_esr0 = v_pre
print meas_vout_pre_v__c330n_esr0
let meas_undershoot_rise_v__c330n_esr0 = v_pre - v_rise_min
print meas_undershoot_rise_v__c330n_esr0
let meas_overshoot_rise_v__c330n_esr0 = v_rise_max - v_pre
print meas_overshoot_rise_v__c330n_esr0
let meas_undershoot_fall_v__c330n_esr0 = v_pre - v_fall_min
print meas_undershoot_fall_v__c330n_esr0
let meas_overshoot_fall_v__c330n_esr0 = v_fall_max - v_pre
print meas_overshoot_fall_v__c330n_esr0
let meas_recovery_rise_us__c330n_esr0 = vecmax(outband*w_rise*(time-1.0m))*1e6
print meas_recovery_rise_us__c330n_esr0
let meas_recovery_fall_us__c330n_esr0 = vecmax(outband*w_fall*(time-2.001m))*1e6
print meas_recovery_fall_us__c330n_esr0
let meas_settle_err_50ma_pct__c330n_esr0 = 100*(v_50ma - v_pre)/v_pre
print meas_settle_err_50ma_pct__c330n_esr0
* --- window leg c330n_esr10m: COUT=3.3e-07 F, ESR=0.01 ohm (independent reset/seed/tran) ---
reset
save all
alter cout = 3.3e-07
alter resr = 0.01
alter cdir = 0.0
tran 200n 3m
meas tran v_pre AVG v(vout) FROM=0.800m TO=0.999m
meas tran v_rise_min MIN v(vout) FROM=1.000m TO=2.001m
meas tran v_rise_max MAX v(vout) FROM=1.000m TO=2.001m
meas tran v_fall_min MIN v(vout) FROM=2.001m TO=2.999m
meas tran v_fall_max MAX v(vout) FROM=2.001m TO=2.999m
meas tran v_50ma FIND v(vout) AT=2.000m
let vpre = v_pre
let dev = abs(v(vout) - vpre)
let band = 0.01 * vpre
let outband = 0.5*(1 + (dev-band)/(abs(dev-band)+1e-18))
let w_rise = 0.5*(1 + (time-1.0m)/(abs(time-1.0m)+1e-18)) * 0.5*(1 + (2.0m-time)/(abs(2.0m-time)+1e-18))
let w_fall = 0.5*(1 + (time-2.001m)/(abs(time-2.001m)+1e-18)) * 0.5*(1 + (2.999m-time)/(abs(2.999m-time)+1e-18))
let meas_vout_pre_v__c330n_esr10m = v_pre
print meas_vout_pre_v__c330n_esr10m
let meas_undershoot_rise_v__c330n_esr10m = v_pre - v_rise_min
print meas_undershoot_rise_v__c330n_esr10m
let meas_overshoot_rise_v__c330n_esr10m = v_rise_max - v_pre
print meas_overshoot_rise_v__c330n_esr10m
let meas_undershoot_fall_v__c330n_esr10m = v_pre - v_fall_min
print meas_undershoot_fall_v__c330n_esr10m
let meas_overshoot_fall_v__c330n_esr10m = v_fall_max - v_pre
print meas_overshoot_fall_v__c330n_esr10m
let meas_recovery_rise_us__c330n_esr10m = vecmax(outband*w_rise*(time-1.0m))*1e6
print meas_recovery_rise_us__c330n_esr10m
let meas_recovery_fall_us__c330n_esr10m = vecmax(outband*w_fall*(time-2.001m))*1e6
print meas_recovery_fall_us__c330n_esr10m
let meas_settle_err_50ma_pct__c330n_esr10m = 100*(v_50ma - v_pre)/v_pre
print meas_settle_err_50ma_pct__c330n_esr10m
* --- window leg c330n_esr500m: COUT=3.3e-07 F, ESR=0.5 ohm (independent reset/seed/tran) ---
reset
save all
alter cout = 3.3e-07
alter resr = 0.5
alter cdir = 0.0
tran 200n 3m
meas tran v_pre AVG v(vout) FROM=0.800m TO=0.999m
meas tran v_rise_min MIN v(vout) FROM=1.000m TO=2.001m
meas tran v_rise_max MAX v(vout) FROM=1.000m TO=2.001m
meas tran v_fall_min MIN v(vout) FROM=2.001m TO=2.999m
meas tran v_fall_max MAX v(vout) FROM=2.001m TO=2.999m
meas tran v_50ma FIND v(vout) AT=2.000m
let vpre = v_pre
let dev = abs(v(vout) - vpre)
let band = 0.01 * vpre
let outband = 0.5*(1 + (dev-band)/(abs(dev-band)+1e-18))
let w_rise = 0.5*(1 + (time-1.0m)/(abs(time-1.0m)+1e-18)) * 0.5*(1 + (2.0m-time)/(abs(2.0m-time)+1e-18))
let w_fall = 0.5*(1 + (time-2.001m)/(abs(time-2.001m)+1e-18)) * 0.5*(1 + (2.999m-time)/(abs(2.999m-time)+1e-18))
let meas_vout_pre_v__c330n_esr500m = v_pre
print meas_vout_pre_v__c330n_esr500m
let meas_undershoot_rise_v__c330n_esr500m = v_pre - v_rise_min
print meas_undershoot_rise_v__c330n_esr500m
let meas_overshoot_rise_v__c330n_esr500m = v_rise_max - v_pre
print meas_overshoot_rise_v__c330n_esr500m
let meas_undershoot_fall_v__c330n_esr500m = v_pre - v_fall_min
print meas_undershoot_fall_v__c330n_esr500m
let meas_overshoot_fall_v__c330n_esr500m = v_fall_max - v_pre
print meas_overshoot_fall_v__c330n_esr500m
let meas_recovery_rise_us__c330n_esr500m = vecmax(outband*w_rise*(time-1.0m))*1e6
print meas_recovery_rise_us__c330n_esr500m
let meas_recovery_fall_us__c330n_esr500m = vecmax(outband*w_fall*(time-2.001m))*1e6
print meas_recovery_fall_us__c330n_esr500m
let meas_settle_err_50ma_pct__c330n_esr500m = 100*(v_50ma - v_pre)/v_pre
print meas_settle_err_50ma_pct__c330n_esr500m
* --- window leg c4u7_esr0: COUT=4.7e-06 F, ESR=0 ohm (independent reset/seed/tran) ---
reset
save all
alter cout = 0.0
alter resr = 0.01
alter cdir = 4.7e-06
tran 200n 3m
meas tran v_pre AVG v(vout) FROM=0.800m TO=0.999m
meas tran v_rise_min MIN v(vout) FROM=1.000m TO=2.001m
meas tran v_rise_max MAX v(vout) FROM=1.000m TO=2.001m
meas tran v_fall_min MIN v(vout) FROM=2.001m TO=2.999m
meas tran v_fall_max MAX v(vout) FROM=2.001m TO=2.999m
meas tran v_50ma FIND v(vout) AT=2.000m
let vpre = v_pre
let dev = abs(v(vout) - vpre)
let band = 0.01 * vpre
let outband = 0.5*(1 + (dev-band)/(abs(dev-band)+1e-18))
let w_rise = 0.5*(1 + (time-1.0m)/(abs(time-1.0m)+1e-18)) * 0.5*(1 + (2.0m-time)/(abs(2.0m-time)+1e-18))
let w_fall = 0.5*(1 + (time-2.001m)/(abs(time-2.001m)+1e-18)) * 0.5*(1 + (2.999m-time)/(abs(2.999m-time)+1e-18))
let meas_vout_pre_v__c4u7_esr0 = v_pre
print meas_vout_pre_v__c4u7_esr0
let meas_undershoot_rise_v__c4u7_esr0 = v_pre - v_rise_min
print meas_undershoot_rise_v__c4u7_esr0
let meas_overshoot_rise_v__c4u7_esr0 = v_rise_max - v_pre
print meas_overshoot_rise_v__c4u7_esr0
let meas_undershoot_fall_v__c4u7_esr0 = v_pre - v_fall_min
print meas_undershoot_fall_v__c4u7_esr0
let meas_overshoot_fall_v__c4u7_esr0 = v_fall_max - v_pre
print meas_overshoot_fall_v__c4u7_esr0
let meas_recovery_rise_us__c4u7_esr0 = vecmax(outband*w_rise*(time-1.0m))*1e6
print meas_recovery_rise_us__c4u7_esr0
let meas_recovery_fall_us__c4u7_esr0 = vecmax(outband*w_fall*(time-2.001m))*1e6
print meas_recovery_fall_us__c4u7_esr0
let meas_settle_err_50ma_pct__c4u7_esr0 = 100*(v_50ma - v_pre)/v_pre
print meas_settle_err_50ma_pct__c4u7_esr0
* --- window leg c4u7_esr10m: COUT=4.7e-06 F, ESR=0.01 ohm (independent reset/seed/tran) ---
reset
save all
alter cout = 4.7e-06
alter resr = 0.01
alter cdir = 0.0
tran 200n 3m
meas tran v_pre AVG v(vout) FROM=0.800m TO=0.999m
meas tran v_rise_min MIN v(vout) FROM=1.000m TO=2.001m
meas tran v_rise_max MAX v(vout) FROM=1.000m TO=2.001m
meas tran v_fall_min MIN v(vout) FROM=2.001m TO=2.999m
meas tran v_fall_max MAX v(vout) FROM=2.001m TO=2.999m
meas tran v_50ma FIND v(vout) AT=2.000m
let vpre = v_pre
let dev = abs(v(vout) - vpre)
let band = 0.01 * vpre
let outband = 0.5*(1 + (dev-band)/(abs(dev-band)+1e-18))
let w_rise = 0.5*(1 + (time-1.0m)/(abs(time-1.0m)+1e-18)) * 0.5*(1 + (2.0m-time)/(abs(2.0m-time)+1e-18))
let w_fall = 0.5*(1 + (time-2.001m)/(abs(time-2.001m)+1e-18)) * 0.5*(1 + (2.999m-time)/(abs(2.999m-time)+1e-18))
let meas_vout_pre_v__c4u7_esr10m = v_pre
print meas_vout_pre_v__c4u7_esr10m
let meas_undershoot_rise_v__c4u7_esr10m = v_pre - v_rise_min
print meas_undershoot_rise_v__c4u7_esr10m
let meas_overshoot_rise_v__c4u7_esr10m = v_rise_max - v_pre
print meas_overshoot_rise_v__c4u7_esr10m
let meas_undershoot_fall_v__c4u7_esr10m = v_pre - v_fall_min
print meas_undershoot_fall_v__c4u7_esr10m
let meas_overshoot_fall_v__c4u7_esr10m = v_fall_max - v_pre
print meas_overshoot_fall_v__c4u7_esr10m
let meas_recovery_rise_us__c4u7_esr10m = vecmax(outband*w_rise*(time-1.0m))*1e6
print meas_recovery_rise_us__c4u7_esr10m
let meas_recovery_fall_us__c4u7_esr10m = vecmax(outband*w_fall*(time-2.001m))*1e6
print meas_recovery_fall_us__c4u7_esr10m
let meas_settle_err_50ma_pct__c4u7_esr10m = 100*(v_50ma - v_pre)/v_pre
print meas_settle_err_50ma_pct__c4u7_esr10m
* --- window leg c4u7_esr500m: COUT=4.7e-06 F, ESR=0.5 ohm (independent reset/seed/tran) ---
reset
save all
alter cout = 4.7e-06
alter resr = 0.5
alter cdir = 0.0
tran 200n 3m
meas tran v_pre AVG v(vout) FROM=0.800m TO=0.999m
meas tran v_rise_min MIN v(vout) FROM=1.000m TO=2.001m
meas tran v_rise_max MAX v(vout) FROM=1.000m TO=2.001m
meas tran v_fall_min MIN v(vout) FROM=2.001m TO=2.999m
meas tran v_fall_max MAX v(vout) FROM=2.001m TO=2.999m
meas tran v_50ma FIND v(vout) AT=2.000m
let vpre = v_pre
let dev = abs(v(vout) - vpre)
let band = 0.01 * vpre
let outband = 0.5*(1 + (dev-band)/(abs(dev-band)+1e-18))
let w_rise = 0.5*(1 + (time-1.0m)/(abs(time-1.0m)+1e-18)) * 0.5*(1 + (2.0m-time)/(abs(2.0m-time)+1e-18))
let w_fall = 0.5*(1 + (time-2.001m)/(abs(time-2.001m)+1e-18)) * 0.5*(1 + (2.999m-time)/(abs(2.999m-time)+1e-18))
let meas_vout_pre_v__c4u7_esr500m = v_pre
print meas_vout_pre_v__c4u7_esr500m
let meas_undershoot_rise_v__c4u7_esr500m = v_pre - v_rise_min
print meas_undershoot_rise_v__c4u7_esr500m
let meas_overshoot_rise_v__c4u7_esr500m = v_rise_max - v_pre
print meas_overshoot_rise_v__c4u7_esr500m
let meas_undershoot_fall_v__c4u7_esr500m = v_pre - v_fall_min
print meas_undershoot_fall_v__c4u7_esr500m
let meas_overshoot_fall_v__c4u7_esr500m = v_fall_max - v_pre
print meas_overshoot_fall_v__c4u7_esr500m
let meas_recovery_rise_us__c4u7_esr500m = vecmax(outband*w_rise*(time-1.0m))*1e6
print meas_recovery_rise_us__c4u7_esr500m
let meas_recovery_fall_us__c4u7_esr500m = vecmax(outband*w_fall*(time-2.001m))*1e6
print meas_recovery_fall_us__c4u7_esr500m
let meas_settle_err_50ma_pct__c4u7_esr500m = 100*(v_50ma - v_pre)/v_pre
print meas_settle_err_50ma_pct__c4u7_esr500m
quit
.endc
.end
