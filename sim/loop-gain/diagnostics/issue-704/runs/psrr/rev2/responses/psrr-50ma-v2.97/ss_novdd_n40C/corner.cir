* klt sim -- generated corner deck, do not edit
.lib /opt/pdk/sky130A/libs.tech/combined/sky130.lib.spice ss
.include /var/tmp/eda-job-klt-sim-c4a494b3e83a/inputs/netlist.cir
.temp -40.0
.meas ac p1k find vdb(vout) at=1000
.meas ac p100k find vdb(vout) at=100000
.control
save all
ac lin 3 1e3 1e5
quit
.endc
.end
